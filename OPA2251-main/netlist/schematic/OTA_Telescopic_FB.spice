** sch_path: /foss/designs/Design/xschem/HPAmplifier/OTA_Telescopic_NO_FLATTEN/Schematics_and_Symbols/OTA_Telescopic_FB.sch
.subckt OTA_Telescopic_FB IB VPout VP VPin VOUTP VDD VOUTN VSS VNin VNout VN CMFBin
*.PININFO VP:I VN:I VOUTP:O VOUTN:O VPin:I VNin:I VPout:O VNout:O VDD:B VSS:B CMFBin:I IB:I
x1 VDD CMFBin VOUTN VOUTP VPin VNin VSS IB OTA_Telescopic_core
R3 VN VNout rppd w=0.6e-6 l=6.73e-6 m=1 b=0
R4 VPout VP rppd w=0.6e-6 l=6.73e-6 m=1 b=0
R5 VOUTP VPout rppd w=0.6e-6 l=19e-6 m=1 b=0
R2 VOUTN VNout rppd w=0.6e-6 l=19e-6 m=1 b=0
.ends

* expanding   symbol:  OTA_Telescopic_core.sym # of pins=8
** sym_path: /foss/designs/Design/xschem/HPAmplifier/OTA_Telescopic_NO_FLATTEN/Schematics_and_Symbols/OTA_Telescopic_core.sym
** sch_path: /foss/designs/Design/xschem/HPAmplifier/OTA_Telescopic_NO_FLATTEN/Schematics_and_Symbols/OTA_Telescopic_core.sch
.subckt OTA_Telescopic_core VDD CMFB VOUTP VOUTN VINP VINN VSS IB
*.PININFO VDD:B VSS:B VINP:I VINN:I VOUTN:O VOUTP:O CMFB:I IB:B
M15 VB55 VB55 VDD VDD sg13_lv_pmos w=1.4u l=0.35u ng=1 m=8
M17 VB33 VB33 VDD VDD sg13_lv_pmos w=2.05u l=0.35u ng=1 m=1
M18 VB22 VB33 VDD VDD sg13_lv_pmos w=2.05u l=0.35u ng=1 m=1
M9 VOUTP Vo1 VDD VDD sg13_lv_pmos w=1.37u l=0.35u ng=1 m=250
M7 Vx1 VB55 VDD VDD sg13_lv_pmos w=7u l=0.7u ng=1 m=30
M5 Vo1 VB33 Vx1 VDD sg13_lv_pmos w=4.05u l=0.5u ng=1 m=30
M8 Vx2 VB55 VDD VDD sg13_lv_pmos w=7u l=0.7u ng=1 m=30
M6 Vo2 VB33 Vx2 VDD sg13_lv_pmos w=4.05u l=0.5u ng=1 m=30
M10 VOUTN Vo2 VDD VDD sg13_lv_pmos w=1.37u l=0.35u ng=1 m=250
M13 IB IB VSS VSS sg13_lv_nmos w=4.8u l=1.06u ng=1 m=1
M14 VB55 IB VSS VSS sg13_lv_nmos w=4.8u l=1.06u ng=1 m=1
M16 VB33 IB VSS VSS sg13_lv_nmos w=4.8u l=1.06u ng=1 m=1
M19 VB22 VB22 VSS VSS sg13_lv_nmos w=0.5u l=0.8u ng=1 m=1
M11 VOUTP IB VSS VSS sg13_lv_nmos w=4.8u l=1.06u ng=1 m=55
M0 P CMFB VSS VSS sg13_lv_nmos w=29.97u l=0.20u ng=9 m=6
M3 Vo1 VB22 Vy1 VSS sg13_lv_nmos w=1.9u l=0.16u ng=1 m=30
M1 Vy1 VINP P VSS sg13_lv_nmos w=1.1u l=0.15u ng=1 m=30
M4 Vo2 VB22 Vy2 VSS sg13_lv_nmos w=1.9u l=0.16u ng=1 m=30
M2 Vy2 VINN P VSS sg13_lv_nmos w=1.1u l=0.15u ng=1 m=30
M12 VOUTN IB VSS VSS sg13_lv_nmos w=4.8u l=1.06u ng=1 m=55
R3 net1 Vo1 rppd w=1.5e-6 l=0.55e-6 m=1 b=0
R1 Vo2 net2 rppd w=1.5e-6 l=0.55e-6 m=1 b=0
C3 net2 VOUTN cap_cmim w=21.4e-6 l=21.4e-6 m=1
C1 net1 VOUTP cap_cmim w=21.4e-6 l=21.4e-6 m=1
.ends
