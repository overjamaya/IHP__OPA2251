** sch_path: /foss/designs/Design/xschem/HPAmplifier/OTA_Telescopic_NO_FLATTEN/Schematics_and_Symbols/Buffer.sch
.subckt Buffer VDD VOUT IB VIN VSS
*.PININFO VDD:B VSS:B VIN:I VOUT:O IB:I
M5 net1 IB VSS VSS sg13_lv_nmos w=3u l=1u ng=1 m=3
M6 IB IB VSS VSS sg13_lv_nmos w=3u l=1u ng=1 m=1
M1 vm VIN net1 VSS sg13_lv_nmos w=10u l=0.5u ng=1 m=16
M2 vota VOUT net1 VSS sg13_lv_nmos w=10u l=0.5u ng=1 m=16
M3 vm vm VDD VDD sg13_lv_pmos w=10u l=1u ng=1 m=4
M4 vota vm VDD VDD sg13_lv_pmos w=10u l=1u ng=1 m=4
M7 VDD vota VOUT VSS sg13_lv_nmos w=10u l=0.15u ng=1 m=25
M8 VOUT IB VSS VSS sg13_lv_nmos w=3u l=1u ng=1 m=1
.ends
