** sch_path: /foss/designs/HPAmplifier/OTA_Telescopic/Schematics_and_Symbols/HPA.sch
.subckt HPA VDD VREF VOUTp VOUTn VINp VINn VSS
*.PININFO VDD:B VSS:B VREF:B VINp:I VINn:I VOUTn:O VOUTp:O
x1 VDD VSS net2 net2 VOUTp VINp VINn VOUTn net3 net3 net1 VREF net1 Vop Von OTA_Telescopic_TOP_wp
* noconn Vop
* noconn Von
.ends

* expanding   symbol:  OTA_Telescopic_TOP_wp.sym # of pins=15
** sym_path: /foss/designs/HPAmplifier/OTA_Telescopic/Schematics_and_Symbols/OTA_Telescopic_TOP_wp.sym
** sch_path: /foss/designs/HPAmplifier/OTA_Telescopic/Schematics_and_Symbols/OTA_Telescopic_TOP_wp.sch
.subckt OTA_Telescopic_TOP_wp VDD VSS VPout VPin VOUTP VP VN VOUTN VNin VNout CMFBin VREF CMFBout Vop Von
*.PININFO VP:I VN:I VOUTP:O VOUTN:O VPin:I VNin:I VPout:O VNout:O VDD:B VSS:B VREF:B CMFBin:I CMFBout:O Von:O Vop:O
x3 VDD I_P I_N VSS I_P2 I_P3 OTA_Telescopic_currentRef
x2 VDD VREF Vop Von I_N CMFBout VSS OTA_Telescopic_CMFB
x1 I_P VPout VP VPin Vop VDD Von VSS VNin VNout VN CMFBin OTA_Telescopic_FB
x4 VDD VOUTN I_P2 Von VSS Buffer
x5 VDD VOUTP I_P3 Vop VSS Buffer
.ends

* expanding   symbol:  OTA_Telescopic_currentRef.sym # of pins=6
** sym_path: /foss/designs/HPAmplifier/OTA_Telescopic/Schematics_and_Symbols/OTA_Telescopic_currentRef.sym
** sch_path: /foss/designs/HPAmplifier/OTA_Telescopic/Schematics_and_Symbols/OTA_Telescopic_currentRef.sch
.subckt OTA_Telescopic_currentRef VDD I_P I_N VSS I_P2 I_P3
*.PININFO VDD:B VSS:B I_P:B I_N:B I_P2:B I_P3:B
M3 net2 net2 VDD VDD sg13_lv_pmos w=12u l=2.5u ng=2
M2 net2 net1 net3 VSS sg13_lv_nmos w=12u l=6.4u ng=2 m=8
M4 net1 net2 VDD VDD sg13_lv_pmos w=12u l=2.5u ng=2
M1 net1 net1 VSS VSS sg13_lv_nmos w=12u l=6.4u ng=2
M5 net2 net2 net1 VSS sg13_lv_nmos w=2u l=1u ng=1
R2 net3 VSS rppd w=1e-6 l=11.5e-6 m=1 b=0
M6 I_P net2 VDD VDD sg13_lv_pmos w=12u l=2.5u ng=2
M7 I_N net1 VSS VSS sg13_lv_nmos w=12u l=6.4u ng=2
M8 I_P2 net2 VDD VDD sg13_lv_pmos w=12u l=2.5u ng=2
M9 I_P3 net2 VDD VDD sg13_lv_pmos w=12u l=2.5u ng=2
.ends

* expanding   symbol:  OTA_Telescopic_CMFB.sym # of pins=7
** sym_path: /foss/designs/HPAmplifier/OTA_Telescopic/Schematics_and_Symbols/OTA_Telescopic_CMFB.sym
** sch_path: /foss/designs/HPAmplifier/OTA_Telescopic/Schematics_and_Symbols/OTA_Telescopic_CMFB.sch
.subckt OTA_Telescopic_CMFB VDD VREF VINN VINP IBIAS CMFB VSS
*.PININFO VDD:B VSS:B CMFB:O VREF:I IBIAS:B VINP:I VINN:I
M0 IBIAS IBIAS VDD VDD sg13_lv_pmos w=6u l=0.7u ng=6 m=8
M1 V1 IBIAS VDD VDD sg13_lv_pmos w=6u l=0.7u ng=6 m=24
M2 V2 IBIAS VDD VDD sg13_lv_pmos w=6u l=0.7u ng=6 m=24
M3 CMFB VINP V1 VDD sg13_lv_pmos w=8.995u l=0.35u ng=7 m=4
M4 net1 VREF V1 VDD sg13_lv_pmos w=8.995u l=0.35u ng=7 m=4
M5 net1 VREF V2 VDD sg13_lv_pmos w=8.995u l=0.35u ng=7 m=4
M6 CMFB VINN V2 VDD sg13_lv_pmos w=8.995u l=0.35u ng=7 m=4
M7 net1 net1 VSS VSS sg13_lv_nmos w=29.97u l=0.20u ng=9
M8 CMFB CMFB VSS VSS sg13_lv_nmos w=29.97u l=0.20u ng=9
.ends

* expanding   symbol:  OTA_Telescopic_FB.sym # of pins=12
** sym_path: /foss/designs/HPAmplifier/OTA_Telescopic/Schematics_and_Symbols/OTA_Telescopic_FB.sym
** sch_path: /foss/designs/HPAmplifier/OTA_Telescopic/Schematics_and_Symbols/OTA_Telescopic_FB.sch
.subckt OTA_Telescopic_FB IB VPout VP VPin VOUTP VDD VOUTN VSS VNin VNout VN CMFBin
*.PININFO VP:I VN:I VOUTP:O VOUTN:O VPin:I VNin:I VPout:O VNout:O VDD:B VSS:B CMFBin:I IB:I
x1 VDD CMFBin VOUTN VOUTP VPin VNin VSS IB OTA_Telescopic_core
R3 VNout VN rppd w=0.6e-6 l=6.73e-6 m=1 b=0
R4 VP VPout rppd w=0.6e-6 l=6.73e-6 m=1 b=0
R5 VPout VOUTP rppd w=0.6e-6 l=19e-6 m=1 b=0
R2 VNout VOUTN rppd w=0.6e-6 l=19e-6 m=1 b=0
.ends

* expanding   symbol:  Buffer.sym # of pins=5
** sym_path: /foss/designs/HPAmplifier/OTA_Telescopic/Schematics_and_Symbols/Buffer.sym
** sch_path: /foss/designs/HPAmplifier/OTA_Telescopic/Schematics_and_Symbols/Buffer.sch
.subckt Buffer VDD VOUT IB VIN VSS
*.PININFO VDD:B VSS:B VIN:I VOUT:O IB:I
M5 net1 IB VSS VSS sg13_lv_nmos w=3u l=1u ng=1 m=3
M6 IB IB VSS VSS sg13_lv_nmos w=3u l=1u ng=1
M1 vm VIN net1 VSS sg13_lv_nmos w=10u l=0.5u ng=1 m=16
M2 vota VOUT net1 VSS sg13_lv_nmos w=10u l=0.5u ng=1 m=16
M3 vm vm VDD VDD sg13_lv_pmos w=10u l=1u ng=1 m=4
M4 vota vm VDD VDD sg13_lv_pmos w=10u l=1u ng=1 m=4
M7 VDD vota VOUT VSS sg13_lv_nmos w=10u l=0.15u ng=1 m=25
M8 VOUT IB VSS VSS sg13_lv_nmos w=3u l=1u ng=1
.ends

* expanding   symbol:  OTA_Telescopic_core.sym # of pins=8
** sym_path: /foss/designs/HPAmplifier/OTA_Telescopic/Schematics_and_Symbols/OTA_Telescopic_core.sym
** sch_path: /foss/designs/HPAmplifier/OTA_Telescopic/Schematics_and_Symbols/OTA_Telescopic_core.sch
.subckt OTA_Telescopic_core VDD CMFB VOUTP VOUTN VINP VINN VSS IB
*.PININFO VDD:B VSS:B VINP:I VINN:I VOUTN:O VOUTP:O CMFB:I IB:B
M15 VB55 VB55 VDD VDD sg13_lv_pmos w=1.4u l=0.35u ng=1 m=8
M17 VB33 VB33 VDD VDD sg13_lv_pmos w=2.05u l=0.35u ng=1
M18 VB22 VB33 VDD VDD sg13_lv_pmos w=2.05u l=0.35u ng=1
M9 VOUTP Vo1 VDD VDD sg13_lv_pmos w=1.37u l=0.35u ng=1 m=250
M7 Vx1 VB55 VDD VDD sg13_lv_pmos w=7u l=0.7u ng=1 m=30
M5 Vo1 VB33 Vx1 VDD sg13_lv_pmos w=4.05u l=0.5u ng=1 m=30
M8 Vx2 VB55 VDD VDD sg13_lv_pmos w=7u l=0.7u ng=1 m=30
M6 Vo2 VB33 Vx2 VDD sg13_lv_pmos w=4.05u l=0.5u ng=1 m=30
M10 VOUTN Vo2 VDD VDD sg13_lv_pmos w=1.37u l=0.35u ng=1 m=250
M13 IB IB VSS VSS sg13_lv_nmos w=4.8u l=1.06u ng=1
M14 VB55 IB VSS VSS sg13_lv_nmos w=4.8u l=1.06u ng=1
M16 VB33 IB VSS VSS sg13_lv_nmos w=4.8u l=1.06u ng=1
M19 VB22 VB22 VSS VSS sg13_lv_nmos w=0.5u l=0.8u ng=1
M11 VOUTP IB VSS VSS sg13_lv_nmos w=4.8u l=1.06u ng=1 m=55
M0 P CMFB VSS VSS sg13_lv_nmos w=29.97u l=0.20u ng=9 m=6
M3 Vo1 VB22 Vy1 VSS sg13_lv_nmos w=1.9u l=0.16u ng=1 m=30
M1 Vy1 VINP P VSS sg13_lv_nmos w=1.1u l=0.15u ng=1 m=30
M4 Vo2 VB22 Vy2 VSS sg13_lv_nmos w=1.9u l=0.16u ng=1 m=30
M2 Vy2 VINN P VSS sg13_lv_nmos w=1.1u l=0.15u ng=1 m=30
M12 VOUTN IB VSS VSS sg13_lv_nmos w=4.8u l=1.06u ng=1 m=55
R3 Vo1 net1 rppd w=1.5e-6 l=0.55e-6 m=1 b=0
R1 net2 Vo2 rppd w=1.5e-6 l=0.55e-6 m=1 b=0
C3 net2 VOUTN cap_cmim w=21.4e-6 l=21.4e-6
C1 net1 VOUTP cap_cmim w=21.4e-6 l=21.4e-6
.ends
