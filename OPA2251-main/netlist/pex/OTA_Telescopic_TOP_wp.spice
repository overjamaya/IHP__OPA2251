* NGSPICE file created from OTA_Telescopic_TOP_wp.ext - technology: ihp-sg13g2

.subckt OTA_Telescopic_TOP_wp VDD VSS VPout VPin VOUTP VP VN VOUTN VNin VNout CMFBin VREF CMFBout Vop Von
X0 a_n3162_51# VPin.t0 a_n1828_1772# VSS.t152 sg13_lv_nmos ad=0.209p pd=1.48u as=0.209p ps=1.48u w=1.1u l=0.15u
X1 Von.t94 a_n10106_3341# VDD.t192 VDD.t1 sg13_lv_pmos ad=0.2603p pd=1.75u as=0.2603p ps=1.75u w=1.37u l=0.35u
X2 Vop.t81 a_1220_1772# VDD.t522 VDD.t1 sg13_lv_pmos ad=0.2603p pd=1.75u as=0.2603p ps=1.75u w=1.37u l=0.35u
X3 VDD.t406 a_1220_1772# Vop.t118 VDD.t1 sg13_lv_pmos ad=0.4658p pd=3.42u as=0.2603p ps=1.75u w=1.37u l=0.35u
X4 a_n2373_n10895# a_n6543_n9623# a_n3721_n10895# VSS.t311 sg13_lv_nmos ad=1.14p pd=6.38u as=2.04p ps=12.68u w=6u l=6.4u
X5 a_1220_1772# a_n9221_n275# a_881_4136# VDD.t1 sg13_lv_pmos ad=0.7695p pd=4.43u as=0.7695p ps=4.43u w=4.05u l=0.5u
X6 VDD.t863 a_n6543_n10895# a_n5006_n3441# VDD.t0 sg13_lv_pmos ad=0.19p pd=1.38u as=0.19p ps=1.38u w=1u l=0.7u
X7 a_881_4136# a_n9221_n275# a_1220_1772# VDD.t1 sg13_lv_pmos ad=1.377p pd=8.78u as=0.7695p ps=4.43u w=4.05u l=0.5u
X8 VDD.t258 a_n10106_3341# Von.t79 VDD.t1 sg13_lv_pmos ad=0.2603p pd=1.75u as=0.2603p ps=1.75u w=1.37u l=0.35u
X9 a_n2002_n4396# a_n6543_n10895# VDD.t829 VDD.t0 sg13_lv_pmos ad=0.19p pd=1.38u as=0.19p ps=1.38u w=1u l=0.7u
X10 a_n2002_n4396# Vop.t158 CMFBout.t10 VDD.t0 sg13_lv_pmos ad=0.24415p pd=1.665u as=0.24415p ps=1.665u w=1.285u l=0.35u
X11 VSS.t10 a_n10179_n275# Vop.t13 VSS.t9 sg13_lv_nmos ad=0.912p pd=5.18u as=0.912p ps=5.18u w=4.8u l=1.06u
X12 a_n1828_1772# VPin.t0 a_n3162_51# VSS.t151 sg13_lv_nmos ad=0.209p pd=1.48u as=0.209p ps=1.48u w=1.1u l=0.15u
X13 Vop.t35 a_1220_1772# VDD.t590 VDD.t1 sg13_lv_pmos ad=0.2603p pd=1.75u as=0.2603p ps=1.75u w=1.37u l=0.35u
X14 a_n3381_1772# a_n9221_n275# a_n10106_3341# VDD.t1 sg13_lv_pmos ad=0.7695p pd=4.43u as=0.7695p ps=4.43u w=4.05u l=0.5u
X15 Vop.t140 a_1220_1772# VDD.t558 VDD.t1 sg13_lv_pmos ad=0.2603p pd=1.75u as=0.2603p ps=1.75u w=1.37u l=0.35u
X16 a_n10106_3341# a_n9221_n275# a_n3381_1772# VDD.t1 sg13_lv_pmos ad=0.7695p pd=4.43u as=1.377p ps=8.78u w=4.05u l=0.5u
X17 VDD.t956 a_n6543_n10895# a_n5006_n3441# VDD.t0 sg13_lv_pmos ad=0.19p pd=1.38u as=0.19p ps=1.38u w=1u l=0.7u
X18 a_n3721_n10895# a_n6543_n9623# a_n2373_n10895# VSS.t318 sg13_lv_nmos ad=2.04p pd=12.68u as=1.14p ps=6.38u w=6u l=6.4u
X19 Von.t153 a_n10106_3341# VDD.t175 VDD.t1 sg13_lv_pmos ad=0.2603p pd=1.75u as=0.4658p ps=3.42u w=1.37u l=0.35u
X20 VDD.t540 a_1220_1772# Vop.t136 VDD.t1 sg13_lv_pmos ad=0.2603p pd=1.75u as=0.2603p ps=1.75u w=1.37u l=0.35u
X21 a_n20570_n9414# VOUTN.t26 a_n14528_n9920# VSS.t257 sg13_lv_nmos ad=1.9p pd=10.38u as=3.4p ps=20.68u w=10u l=0.5u
X22 a_286_1773# VNin.t0 a_n3162_51# VSS.t142 sg13_lv_nmos ad=0.209p pd=1.48u as=0.374p ps=2.88u w=1.1u l=0.15u
X23 a_n3721_n10895# a_n6543_n9623# a_n2373_n10895# VSS.t318 sg13_lv_nmos ad=2.04p pd=12.68u as=1.14p ps=6.38u w=6u l=6.4u
X24 Vop.t74 a_1220_1772# VDD.t467 VDD.t1 sg13_lv_pmos ad=0.2603p pd=1.75u as=0.4658p ps=3.42u w=1.37u l=0.35u
X25 VDD.t790 a_n6543_n10895# a_n2002_n4396# VDD.t0 sg13_lv_pmos ad=0.19p pd=1.38u as=0.19p ps=1.38u w=1u l=0.7u
X26 VDD.t667 a_n6543_n10895# a_n6543_n10895# VDD.t0 sg13_lv_pmos ad=0.19p pd=1.38u as=0.19p ps=1.38u w=1u l=0.7u
X27 a_n14528_n9920# Von.t157 a_n14155_n5285# VSS.t304 sg13_lv_nmos ad=1.9p pd=10.38u as=1.9p ps=10.38u w=10u l=0.5u
X28 VDD.t454 a_1220_1772# Vop.t89 VDD.t1 sg13_lv_pmos ad=0.2603p pd=1.75u as=0.2603p ps=1.75u w=1.37u l=0.35u
X29 Von.t11 a_n10179_n275# VSS.t43 VSS.t19 sg13_lv_nmos ad=0.912p pd=5.18u as=0.912p ps=5.18u w=4.8u l=1.06u
X30 VDD.t927 a_n6543_n10895# a_n2002_n4396# VDD.t0 sg13_lv_pmos ad=0.19p pd=1.38u as=0.19p ps=1.38u w=1u l=0.7u
X31 VDD.t962 a_n6543_n10895# a_n5006_n3441# VDD.t0 sg13_lv_pmos ad=0.19p pd=1.38u as=0.19p ps=1.38u w=1u l=0.7u
X32 a_n2002_n4396# a_n6543_n10895# VDD.t881 VDD.t0 sg13_lv_pmos ad=0.19p pd=1.38u as=0.19p ps=1.38u w=1u l=0.7u
X33 Vop.t142 a_1220_1772# VDD.t434 VDD.t1 sg13_lv_pmos ad=0.2603p pd=1.75u as=0.2603p ps=1.75u w=1.37u l=0.35u
X34 VDD.t827 a_n6543_n10895# a_n2002_n4396# VDD.t0 sg13_lv_pmos ad=0.19p pd=1.38u as=0.19p ps=1.38u w=1u l=0.7u
X35 Von.t54 a_n10106_3341# VDD.t132 VDD.t1 sg13_lv_pmos ad=0.2603p pd=1.75u as=0.2603p ps=1.75u w=1.37u l=0.35u
X36 VDD.t398 a_1220_1772# Vop.t124 VDD.t1 sg13_lv_pmos ad=0.2603p pd=1.75u as=0.2603p ps=1.75u w=1.37u l=0.35u
X37 VDD.t510 a_1220_1772# Vop.t71 VDD.t1 sg13_lv_pmos ad=0.2603p pd=1.75u as=0.2603p ps=1.75u w=1.37u l=0.35u
X38 VDD.t476 a_1220_1772# Vop.t58 VDD.t1 sg13_lv_pmos ad=0.4658p pd=3.42u as=0.2603p ps=1.75u w=1.37u l=0.35u
X39 a_n2002_n4396# a_n6543_n10895# VDD.t978 VDD.t0 sg13_lv_pmos ad=0.19p pd=1.38u as=0.19p ps=1.38u w=1u l=0.7u
X40 VDD.t59 a_n10013_2465# a_881_4136# VDD.t1 sg13_lv_pmos ad=1.33p pd=7.38u as=1.33p ps=7.38u w=7u l=0.7u
X41 CMFBout.t25 Von.t158 a_n5006_n3441# VDD.t0 sg13_lv_pmos ad=0.24415p pd=1.665u as=0.24415p ps=1.665u w=1.285u l=0.35u
X42 CMFBout.t14 Vop.t158 a_n2002_n4396# VDD.t0 sg13_lv_pmos ad=0.24415p pd=1.665u as=0.24415p ps=1.665u w=1.285u l=0.35u
X43 VDD.t691 a_n6543_n10895# a_n6543_n10895# VDD.t0 sg13_lv_pmos ad=0.19p pd=1.38u as=0.19p ps=1.38u w=1u l=0.7u
X44 VDD.t302 a_n10106_3341# Von.t131 VDD.t1 sg13_lv_pmos ad=0.2603p pd=1.75u as=0.2603p ps=1.75u w=1.37u l=0.35u
X45 Vop.t9 a_n10179_n275# VSS.t126 VSS.t9 sg13_lv_nmos ad=0.912p pd=5.18u as=0.912p ps=5.18u w=4.8u l=1.06u
X46 VDD.t43 a_n10013_2465# a_881_4136# VDD.t1 sg13_lv_pmos ad=1.33p pd=7.38u as=1.33p ps=7.38u w=7u l=0.7u
X47 VOUTN.t5 a_n20570_n9414# VDD.t82 VSS.t137 sg13_lv_nmos ad=3.4p pd=20.68u as=3.4p ps=20.68u w=10u l=0.15u
X48 a_1220_1772# a_n9221_n275# a_881_4136# VDD.t1 sg13_lv_pmos ad=0.7695p pd=4.43u as=0.7695p ps=4.43u w=4.05u l=0.5u
X49 Von.t48 a_n10106_3341# VDD.t286 VDD.t1 sg13_lv_pmos ad=0.2603p pd=1.75u as=0.2603p ps=1.75u w=1.37u l=0.35u
X50 a_286_1773# VNin.t0 a_n3162_51# VSS.t142 sg13_lv_nmos ad=0.209p pd=1.48u as=0.374p ps=2.88u w=1.1u l=0.15u
X51 VDD.t741 a_n6543_n10895# a_n2002_n4396# VDD.t0 sg13_lv_pmos ad=0.19p pd=1.38u as=0.19p ps=1.38u w=1u l=0.7u
X52 a_n3381_1772# a_n9221_n275# a_n10106_3341# VDD.t1 sg13_lv_pmos ad=0.7695p pd=4.43u as=0.7695p ps=4.43u w=4.05u l=0.5u
X53 VSS.t309 a_n6543_n9623# a_n6543_n9623# VSS.t308 sg13_lv_nmos ad=1.14p pd=6.38u as=2.04p ps=12.68u w=6u l=6.4u
X54 VSS.t118 a_n10179_n275# Vop.t25 VSS.t63 sg13_lv_nmos ad=0.912p pd=5.18u as=0.912p ps=5.18u w=4.8u l=1.06u
X55 a_36_n4396# VREF.t0 a_n2002_n4396# VDD.t0 sg13_lv_pmos ad=0.24415p pd=1.665u as=0.24415p ps=1.665u w=1.285u l=0.35u
X56 a_n3162_51# CMFBin.t16 VSS.t207 VSS.t208 sg13_lv_nmos ad=0.6327p pd=3.71u as=0.6327p ps=3.71u w=3.33u l=0.2u
X57 a_286_1773# a_n8929_2739# a_1220_1772# VSS.t333 sg13_lv_nmos ad=0.646p pd=4.48u as=0.361p ps=2.28u w=1.9u l=0.16u
X58 VDD.t524 a_1220_1772# Vop.t81 VDD.t1 sg13_lv_pmos ad=0.2603p pd=1.75u as=0.2603p ps=1.75u w=1.37u l=0.35u
X59 VDD.t85 a_n20570_n9414# VOUTN.t3 VSS.t140 sg13_lv_nmos ad=3.4p pd=20.68u as=3.4p ps=20.68u w=10u l=0.15u
X60 VDD.t778 a_n6543_n10895# a_n2002_n4396# VDD.t0 sg13_lv_pmos ad=0.19p pd=1.38u as=0.19p ps=1.38u w=1u l=0.7u
X61 a_n1828_1772# VPin.t0 a_n3162_51# VSS.t153 sg13_lv_nmos ad=0.209p pd=1.48u as=0.209p ps=1.48u w=1.1u l=0.15u
X62 VDD.t908 a_n6543_n10895# a_n5006_n3441# VDD.t0 sg13_lv_pmos ad=0.19p pd=1.38u as=0.19p ps=1.38u w=1u l=0.7u
X63 VDD.t468 a_1220_1772# Vop.t74 VDD.t1 sg13_lv_pmos ad=0.2603p pd=1.75u as=0.2603p ps=1.75u w=1.37u l=0.35u
X64 Von.t79 a_n10106_3341# VDD.t256 VDD.t1 sg13_lv_pmos ad=0.2603p pd=1.75u as=0.2603p ps=1.75u w=1.37u l=0.35u
X65 a_n14528_n9920# VOUTN.t26 a_n20570_n9414# VSS.t258 sg13_lv_nmos ad=1.9p pd=10.38u as=1.9p ps=10.38u w=10u l=0.5u
X66 Von.t6 a_n10179_n275# VSS.t50 VSS.t13 sg13_lv_nmos ad=0.912p pd=5.18u as=0.912p ps=5.18u w=4.8u l=1.06u
X67 VSS.t32 a_n10179_n275# Von.t25 VSS.t17 sg13_lv_nmos ad=0.912p pd=5.18u as=0.912p ps=5.18u w=4.8u l=1.06u
X68 a_n5006_n3441# a_n6543_n10895# VDD.t728 VDD.t0 sg13_lv_pmos ad=0.19p pd=1.38u as=0.34p ps=2.68u w=1u l=0.7u
X69 VDD.t280 a_n10106_3341# Von.t46 VDD.t1 sg13_lv_pmos ad=0.2603p pd=1.75u as=0.2603p ps=1.75u w=1.37u l=0.35u
X70 a_n3162_51# CMFBin.t11 VSS.t222 VSS.t223 sg13_lv_nmos ad=0.6327p pd=3.71u as=0.6327p ps=3.71u w=3.33u l=0.2u
X71 VDD.t252 a_n10106_3341# Von.t99 VDD.t1 sg13_lv_pmos ad=0.2603p pd=1.75u as=0.2603p ps=1.75u w=1.37u l=0.35u
X72 Vop.t154 a_1220_1772# VDD.t378 VDD.t1 sg13_lv_pmos ad=0.2603p pd=1.75u as=0.2603p ps=1.75u w=1.37u l=0.35u
X73 a_1220_1772# a_n9221_n275# a_881_4136# VDD.t1 sg13_lv_pmos ad=0.7695p pd=4.43u as=1.377p ps=8.78u w=4.05u l=0.5u
X74 Von.t82 a_n10106_3341# VDD.t212 VDD.t1 sg13_lv_pmos ad=0.2603p pd=1.75u as=0.2603p ps=1.75u w=1.37u l=0.35u
X75 a_n20570_n9414# VOUTN.t26 a_n14528_n9920# VSS.t263 sg13_lv_nmos ad=1.9p pd=10.38u as=1.9p ps=10.38u w=10u l=0.5u
X76 a_n3162_51# VPin.t0 a_n1828_1772# VSS.t154 sg13_lv_nmos ad=0.374p pd=2.88u as=0.209p ps=1.48u w=1.1u l=0.15u
X77 VDD.t164 a_n10106_3341# Von.t101 VDD.t1 sg13_lv_pmos ad=0.4658p pd=3.42u as=0.2603p ps=1.75u w=1.37u l=0.35u
X78 VDD.t598 a_13228_n9920# VOUTP.t1 VSS.t168 sg13_lv_nmos ad=3.4p pd=20.68u as=3.4p ps=20.68u w=10u l=0.15u
X79 a_n3381_1772# a_n9221_n275# a_n10106_3341# VDD.t1 sg13_lv_pmos ad=1.377p pd=8.78u as=0.7695p ps=4.43u w=4.05u l=0.5u
X80 VDD.t914 a_n6543_n10895# a_n5006_n3441# VDD.t0 sg13_lv_pmos ad=0.19p pd=1.38u as=0.19p ps=1.38u w=1u l=0.7u
X81 VSS.t58 a_n10179_n275# Von.t4 VSS.t23 sg13_lv_nmos ad=0.912p pd=5.18u as=0.912p ps=5.18u w=4.8u l=1.06u
X82 VDD.t815 a_n6543_n10895# a_n5006_n3441# VDD.t0 sg13_lv_pmos ad=0.19p pd=1.38u as=0.19p ps=1.38u w=1u l=0.7u
X83 a_n3381_1772# a_n10013_2465# VDD.t20 VDD.t1 sg13_lv_pmos ad=1.33p pd=7.38u as=2.38p ps=14.68u w=7u l=0.7u
X84 a_11652_n9920# Vop.t157 a_11820_n9920# VSS.t158 sg13_lv_nmos ad=1.9p pd=10.38u as=1.9p ps=10.38u w=10u l=0.5u
X85 a_36_n4396# a_36_n4396# VSS.t348 VSS.t349 sg13_lv_nmos ad=1.1322p pd=7.34u as=0.6327p ps=3.71u w=3.33u l=0.2u
X86 a_n6543_n10895# a_n6543_n10895# VDD.t661 VDD.t0 sg13_lv_pmos ad=0.19p pd=1.38u as=0.19p ps=1.38u w=1u l=0.7u
X87 CMFBout.t3 Vop.t158 a_n2002_n4396# VDD.t0 sg13_lv_pmos ad=0.24415p pd=1.665u as=0.24415p ps=1.665u w=1.285u l=0.35u
X88 a_n6543_n10895# a_n6543_n10895# VDD.t675 VDD.t0 sg13_lv_pmos ad=0.19p pd=1.38u as=0.19p ps=1.38u w=1u l=0.7u
X89 a_n2002_n4396# a_n6543_n10895# VDD.t931 VDD.t0 sg13_lv_pmos ad=0.19p pd=1.38u as=0.19p ps=1.38u w=1u l=0.7u
X90 VDD.t721 a_n6543_n10895# a_n5006_n3441# VDD.t0 sg13_lv_pmos ad=0.19p pd=1.38u as=0.19p ps=1.38u w=1u l=0.7u
X91 Vop.t150 a_1220_1772# VDD.t578 VDD.t1 sg13_lv_pmos ad=0.2603p pd=1.75u as=0.2603p ps=1.75u w=1.37u l=0.35u
X92 CMFBout.t0 Von.t158 a_n5006_n3441# VDD.t0 sg13_lv_pmos ad=0.24415p pd=1.665u as=0.24415p ps=1.665u w=1.285u l=0.35u
X93 VDD.t286 a_n10106_3341# Von.t132 VDD.t1 sg13_lv_pmos ad=0.2603p pd=1.75u as=0.2603p ps=1.75u w=1.37u l=0.35u
X94 VDD.t616 a_13228_n9920# VOUTP.t18 VSS.t170 sg13_lv_nmos ad=3.4p pd=20.68u as=3.4p ps=20.68u w=10u l=0.15u
X95 Vop.t80 a_1220_1772# VDD.t487 VDD.t1 sg13_lv_pmos ad=0.2603p pd=1.75u as=0.4658p ps=3.42u w=1.37u l=0.35u
X96 VDD.t821 a_n6543_n10895# a_n5006_n3441# VDD.t0 sg13_lv_pmos ad=0.19p pd=1.38u as=0.19p ps=1.38u w=1u l=0.7u
X97 IB.t0 a_n3721_n10895# VDD.t630 VDD.t622 sg13_lv_pmos ad=1.14p pd=6.38u as=1.14p ps=6.38u w=6u l=2.5u
X98 VDD.t69 a_n10013_2465# a_881_4136# VDD.t1 sg13_lv_pmos ad=2.38p pd=14.68u as=1.33p ps=7.38u w=7u l=0.7u
X99 VDD.t851 a_n6543_n10895# a_n5006_n3441# VDD.t0 sg13_lv_pmos ad=0.19p pd=1.38u as=0.19p ps=1.38u w=1u l=0.7u
X100 VDD.t322 a_n10106_3341# Von.t129 VDD.t1 sg13_lv_pmos ad=0.2603p pd=1.75u as=0.2603p ps=1.75u w=1.37u l=0.35u
X101 a_n2002_n4396# a_n6543_n10895# VDD.t840 VDD.t0 sg13_lv_pmos ad=0.19p pd=1.38u as=0.19p ps=1.38u w=1u l=0.7u
X102 VDD.t727 a_n6543_n10895# a_n5006_n3441# VDD.t0 sg13_lv_pmos ad=0.19p pd=1.38u as=0.19p ps=1.38u w=1u l=0.7u
X103 a_n5006_n3441# VREF.t0 a_36_n4396# VDD.t0 sg13_lv_pmos ad=0.24415p pd=1.665u as=0.4369p ps=3.25u w=1.285u l=0.35u
X104 VDD.t697 a_n6543_n10895# a_n6543_n10895# VDD.t0 sg13_lv_pmos ad=0.19p pd=1.38u as=0.19p ps=1.38u w=1u l=0.7u
X105 VDD.t496 a_1220_1772# Vop.t53 VDD.t1 sg13_lv_pmos ad=0.4658p pd=3.42u as=0.2603p ps=1.75u w=1.37u l=0.35u
X106 VDD.t256 a_n10106_3341# Von.t78 VDD.t1 sg13_lv_pmos ad=0.2603p pd=1.75u as=0.2603p ps=1.75u w=1.37u l=0.35u
X107 Von.t151 a_n10106_3341# VDD.t170 VDD.t1 sg13_lv_pmos ad=0.2603p pd=1.75u as=0.2603p ps=1.75u w=1.37u l=0.35u
X108 a_13228_n9920# a_11820_n9920# VDD.t635 VDD.t633 sg13_lv_pmos ad=1.9p pd=10.38u as=1.9p ps=10.38u w=10u l=1u
X109 a_n2002_n4396# a_n6543_n10895# VDD.t745 VDD.t0 sg13_lv_pmos ad=0.19p pd=1.38u as=0.19p ps=1.38u w=1u l=0.7u
X110 a_36_n4396# VREF.t0 a_n5006_n3441# VDD.t0 sg13_lv_pmos ad=0.24415p pd=1.665u as=0.24415p ps=1.665u w=1.285u l=0.35u
X111 a_n6543_n10895# a_n6543_n10895# VDD.t685 VDD.t0 sg13_lv_pmos ad=0.19p pd=1.38u as=0.19p ps=1.38u w=1u l=0.7u
X112 VDD.t25 a_n10013_2465# a_n3381_1772# VDD.t1 sg13_lv_pmos ad=2.38p pd=14.68u as=1.33p ps=7.38u w=7u l=0.7u
X113 Von.t118 a_n10106_3341# VDD.t108 VDD.t1 sg13_lv_pmos ad=0.2603p pd=1.75u as=0.2603p ps=1.75u w=1.37u l=0.35u
X114 a_n10013_2465# a_n10013_2465# VDD.t31 VDD.t1 sg13_lv_pmos ad=0.266p pd=1.78u as=0.476p ps=3.48u w=1.4u l=0.35u
X115 VSS.t89 a_n10179_n275# Vop.t1 VSS.t9 sg13_lv_nmos ad=0.912p pd=5.18u as=0.912p ps=5.18u w=4.8u l=1.06u
X116 a_n5006_n3441# Von.t158 CMFBout.t18 VDD.t0 sg13_lv_pmos ad=0.24415p pd=1.665u as=0.24415p ps=1.665u w=1.285u l=0.35u
X117 a_36_n4396# a_36_n4396# VSS.t342 VSS.t343 sg13_lv_nmos ad=0.6327p pd=3.71u as=0.6327p ps=3.71u w=3.33u l=0.2u
X118 Vop.t147 a_1220_1772# VDD.t560 VDD.t1 sg13_lv_pmos ad=0.2603p pd=1.75u as=0.2603p ps=1.75u w=1.37u l=0.35u
X119 VDD.t542 a_1220_1772# Vop.t137 VDD.t1 sg13_lv_pmos ad=0.2603p pd=1.75u as=0.2603p ps=1.75u w=1.37u l=0.35u
X120 a_n14528_n9920# a_n13845_n10915# VSS.t268 VSS.t267 sg13_lv_nmos ad=0.57p pd=3.38u as=0.57p ps=3.38u w=3u l=1u
X121 Von.t111 a_n10106_3341# VDD.t145 VDD.t1 sg13_lv_pmos ad=0.2603p pd=1.75u as=0.4658p ps=3.42u w=1.37u l=0.35u
X122 Vop.t131 a_1220_1772# VDD.t437 VDD.t1 sg13_lv_pmos ad=0.2603p pd=1.75u as=0.4658p ps=3.42u w=1.37u l=0.35u
X123 Von.t46 a_n10106_3341# VDD.t278 VDD.t1 sg13_lv_pmos ad=0.2603p pd=1.75u as=0.2603p ps=1.75u w=1.37u l=0.35u
X124 a_n5006_n3441# a_n6543_n10895# VDD.t952 VDD.t0 sg13_lv_pmos ad=0.19p pd=1.38u as=0.19p ps=1.38u w=1u l=0.7u
X125 a_n3162_51# VPin.t0 a_n1828_1772# VSS.t154 sg13_lv_nmos ad=0.374p pd=2.88u as=0.209p ps=1.48u w=1.1u l=0.15u
X126 Vop.t118 a_1220_1772# VDD.t404 VDD.t1 sg13_lv_pmos ad=0.2603p pd=1.75u as=0.2603p ps=1.75u w=1.37u l=0.35u
X127 a_n2002_n4396# VREF.t0 a_36_n4396# VDD.t0 sg13_lv_pmos ad=0.24415p pd=1.665u as=0.24415p ps=1.665u w=1.285u l=0.35u
X128 VDD.t512 a_1220_1772# Vop.t55 VDD.t1 sg13_lv_pmos ad=0.2603p pd=1.75u as=0.2603p ps=1.75u w=1.37u l=0.35u
X129 VDD.t446 a_1220_1772# Vop.t101 VDD.t1 sg13_lv_pmos ad=0.4658p pd=3.42u as=0.2603p ps=1.75u w=1.37u l=0.35u
X130 Vop.t51 a_1220_1772# VDD.t360 VDD.t1 sg13_lv_pmos ad=0.2603p pd=1.75u as=0.2603p ps=1.75u w=1.37u l=0.35u
X131 VDD.t488 a_1220_1772# Vop.t80 VDD.t1 sg13_lv_pmos ad=0.2603p pd=1.75u as=0.2603p ps=1.75u w=1.37u l=0.35u
X132 a_n2002_n4396# VREF.t0 a_36_n4396# VDD.t0 sg13_lv_pmos ad=0.24415p pd=1.665u as=0.24415p ps=1.665u w=1.285u l=0.35u
X133 a_n5006_n3441# a_n6543_n10895# VDD.t809 VDD.t0 sg13_lv_pmos ad=0.19p pd=1.38u as=0.19p ps=1.38u w=1u l=0.7u
X134 a_n3162_51# CMFBin.t15 VSS.t210 VSS.t211 sg13_lv_nmos ad=0.6327p pd=3.71u as=0.6327p ps=3.71u w=3.33u l=0.2u
X135 VDD.t300 a_n10106_3341# Von.t133 VDD.t1 sg13_lv_pmos ad=0.2603p pd=1.75u as=0.2603p ps=1.75u w=1.37u l=0.35u
X136 Von.t33 a_n10106_3341# VDD.t120 VDD.t1 sg13_lv_pmos ad=0.2603p pd=1.75u as=0.2603p ps=1.75u w=1.37u l=0.35u
X137 VDD.t632 a_n3721_n10895# IB.t0 VDD.t622 sg13_lv_pmos ad=2.04p pd=12.68u as=1.14p ps=6.38u w=6u l=2.5u
X138 VSS.t186 CMFBin.t23 a_n3162_51# VSS.t185 sg13_lv_nmos ad=0.6327p pd=3.71u as=0.6327p ps=3.71u w=3.33u l=0.2u
X139 Von.t76 a_n10106_3341# VDD.t232 VDD.t1 sg13_lv_pmos ad=0.2603p pd=1.75u as=0.2603p ps=1.75u w=1.37u l=0.35u
X140 VDD.t49 a_n10013_2465# a_881_4136# VDD.t1 sg13_lv_pmos ad=1.33p pd=7.38u as=1.33p ps=7.38u w=7u l=0.7u
X141 VDD.t982 a_n6543_n10895# a_n2002_n4396# VDD.t0 sg13_lv_pmos ad=0.19p pd=1.38u as=0.19p ps=1.38u w=1u l=0.7u
X142 VSS.t231 CMFBin.t8 a_n3162_51# VSS.t230 sg13_lv_nmos ad=0.6327p pd=3.71u as=0.6327p ps=3.71u w=3.33u l=0.2u
X143 a_n6543_n10895# a_n6543_n10895# VDD.t693 VDD.t0 sg13_lv_pmos ad=0.19p pd=1.38u as=0.19p ps=1.38u w=1u l=0.7u
X144 VDD.t968 a_n6543_n10895# a_n2002_n4396# VDD.t0 sg13_lv_pmos ad=0.19p pd=1.38u as=0.19p ps=1.38u w=1u l=0.7u
X145 VDD.t184 a_n10106_3341# Von.t90 VDD.t1 sg13_lv_pmos ad=0.4658p pd=3.42u as=0.2603p ps=1.75u w=1.37u l=0.35u
X146 Von.t103 a_n10106_3341# VDD.t215 VDD.t1 sg13_lv_pmos ad=0.2603p pd=1.75u as=0.4658p ps=3.42u w=1.37u l=0.35u
X147 Vop.t2 a_n10179_n275# VSS.t10 VSS.t9 sg13_lv_nmos ad=0.912p pd=5.18u as=0.912p ps=5.18u w=4.8u l=1.06u
X148 a_n3721_n10895# a_n6543_n9623# a_n2373_n10895# VSS.t312 sg13_lv_nmos ad=1.14p pd=6.38u as=1.14p ps=6.38u w=6u l=6.4u
X149 VDD.t819 a_n6543_n10895# a_n5006_n3441# VDD.t0 sg13_lv_pmos ad=0.19p pd=1.38u as=0.19p ps=1.38u w=1u l=0.7u
X150 a_n3381_1772# a_n10013_2465# VDD.t17 VDD.t1 sg13_lv_pmos ad=1.33p pd=7.38u as=1.33p ps=7.38u w=7u l=0.7u
X151 VOUTP.t12 a_13228_n9920# VDD.t605 VSS.t167 sg13_lv_nmos ad=3.4p pd=20.68u as=3.4p ps=20.68u w=10u l=0.15u
X152 a_n5006_n3441# a_n6543_n10895# VDD.t859 VDD.t0 sg13_lv_pmos ad=0.19p pd=1.38u as=0.19p ps=1.38u w=1u l=0.7u
X153 Vop.t146 a_1220_1772# VDD.t542 VDD.t1 sg13_lv_pmos ad=0.2603p pd=1.75u as=0.2603p ps=1.75u w=1.37u l=0.35u
X154 a_n5006_n3441# VREF.t0 a_36_n4396# VDD.t0 sg13_lv_pmos ad=0.24415p pd=1.665u as=0.24415p ps=1.665u w=1.285u l=0.35u
X155 Vop.t58 a_1220_1772# VDD.t474 VDD.t1 sg13_lv_pmos ad=0.2603p pd=1.75u as=0.2603p ps=1.75u w=1.37u l=0.35u
X156 Von.t58 a_n10106_3341# VDD.t100 VDD.t1 sg13_lv_pmos ad=0.2603p pd=1.75u as=0.2603p ps=1.75u w=1.37u l=0.35u
X157 a_n20570_n9414# VOUTN.t26 a_n14528_n9920# VSS.t259 sg13_lv_nmos ad=1.9p pd=10.38u as=1.9p ps=10.38u w=10u l=0.5u
X158 Vop.t17 a_n10179_n275# VSS.t107 VSS.t9 sg13_lv_nmos ad=0.912p pd=5.18u as=0.912p ps=5.18u w=4.8u l=1.06u
X159 VDD.t438 a_1220_1772# Vop.t131 VDD.t1 sg13_lv_pmos ad=0.2603p pd=1.75u as=0.2603p ps=1.75u w=1.37u l=0.35u
X160 VSS.t43 a_n10179_n275# Von.t10 VSS.t17 sg13_lv_nmos ad=0.912p pd=5.18u as=0.912p ps=5.18u w=4.8u l=1.06u
X161 VDD.t278 a_n10106_3341# Von.t45 VDD.t1 sg13_lv_pmos ad=0.2603p pd=1.75u as=0.2603p ps=1.75u w=1.37u l=0.35u
X162 a_n5006_n3441# a_n6543_n10895# VDD.t763 VDD.t0 sg13_lv_pmos ad=0.19p pd=1.38u as=0.19p ps=1.38u w=1u l=0.7u
X163 VDD.t250 a_n10106_3341# Von.t39 VDD.t1 sg13_lv_pmos ad=0.2603p pd=1.75u as=0.2603p ps=1.75u w=1.37u l=0.35u
X164 a_n5006_n3441# a_n6543_n10895# VDD.t904 VDD.t0 sg13_lv_pmos ad=0.19p pd=1.38u as=0.19p ps=1.38u w=1u l=0.7u
X165 VDD.t342 a_n10106_3341# Von.t141 VDD.t1 sg13_lv_pmos ad=0.2603p pd=1.75u as=0.2603p ps=1.75u w=1.37u l=0.35u
X166 a_n2002_n4396# a_n6543_n10895# VDD.t657 VDD.t0 sg13_lv_pmos ad=0.19p pd=1.38u as=0.19p ps=1.38u w=1u l=0.7u
X167 a_n6543_n10895# a_n6543_n10895# VDD.t663 VDD.t0 sg13_lv_pmos ad=0.19p pd=1.38u as=0.19p ps=1.38u w=1u l=0.7u
X168 Vop.t56 a_1220_1772# VDD.t512 VDD.t1 sg13_lv_pmos ad=0.2603p pd=1.75u as=0.2603p ps=1.75u w=1.37u l=0.35u
X169 a_11652_n9920# Vop.t157 a_11820_n9920# VSS.t164 sg13_lv_nmos ad=1.9p pd=10.38u as=1.9p ps=10.38u w=10u l=0.5u
X170 Von.t30 a_n10106_3341# VDD.t105 VDD.t1 sg13_lv_pmos ad=0.2603p pd=1.75u as=0.4658p ps=3.42u w=1.37u l=0.35u
X171 VDD.t624 a_n3721_n10895# a_n6543_n9623# VDD.t622 sg13_lv_pmos ad=1.14p pd=6.38u as=1.14p ps=6.38u w=6u l=2.5u
X172 VDD.t372 a_1220_1772# Vop.t109 VDD.t1 sg13_lv_pmos ad=0.2603p pd=1.75u as=0.2603p ps=1.75u w=1.37u l=0.35u
X173 VSS.t342 a_36_n4396# a_36_n4396# VSS.t341 sg13_lv_nmos ad=0.6327p pd=3.71u as=0.6327p ps=3.71u w=3.33u l=0.2u
X174 VDD.t21 a_n10013_2465# a_n3381_1772# VDD.t1 sg13_lv_pmos ad=1.33p pd=7.38u as=1.33p ps=7.38u w=7u l=0.7u
X175 Vop.t129 a_1220_1772# VDD.t580 VDD.t1 sg13_lv_pmos ad=0.2603p pd=1.75u as=0.2603p ps=1.75u w=1.37u l=0.35u
X176 VDD.t798 a_n6543_n10895# a_n2002_n4396# VDD.t0 sg13_lv_pmos ad=0.19p pd=1.38u as=0.19p ps=1.38u w=1u l=0.7u
X177 Vop.t43 a_1220_1772# VDD.t362 VDD.t1 sg13_lv_pmos ad=0.2603p pd=1.75u as=0.2603p ps=1.75u w=1.37u l=0.35u
X178 VDD.t530 a_1220_1772# Vop.t85 VDD.t1 sg13_lv_pmos ad=0.2603p pd=1.75u as=0.2603p ps=1.75u w=1.37u l=0.35u
X179 VSS.t50 a_n10179_n275# Von.t5 VSS.t11 sg13_lv_nmos ad=0.912p pd=5.18u as=1.632p ps=10.28u w=4.8u l=1.06u
X180 VDD.t935 a_n6543_n10895# a_n2002_n4396# VDD.t0 sg13_lv_pmos ad=0.19p pd=1.38u as=0.19p ps=1.38u w=1u l=0.7u
X181 VDD.t920 a_n6543_n10895# a_n2002_n4396# VDD.t0 sg13_lv_pmos ad=0.19p pd=1.38u as=0.19p ps=1.38u w=1u l=0.7u
X182 Vop.t141 a_1220_1772# VDD.t457 VDD.t1 sg13_lv_pmos ad=0.2603p pd=1.75u as=0.4658p ps=3.42u w=1.37u l=0.35u
X183 a_n5006_n3441# a_n6543_n10895# VDD.t717 VDD.t0 sg13_lv_pmos ad=0.19p pd=1.38u as=0.19p ps=1.38u w=1u l=0.7u
X184 a_n6543_n10895# a_n6543_n10895# VDD.t679 VDD.t0 sg13_lv_pmos ad=0.19p pd=1.38u as=0.19p ps=1.38u w=1u l=0.7u
X185 Von.t133 a_n10106_3341# VDD.t298 VDD.t1 sg13_lv_pmos ad=0.2603p pd=1.75u as=0.2603p ps=1.75u w=1.37u l=0.35u
X186 VDD.t320 a_n10106_3341# Von.t64 VDD.t1 sg13_lv_pmos ad=0.2603p pd=1.75u as=0.2603p ps=1.75u w=1.37u l=0.35u
X187 a_881_4136# a_n10013_2465# VDD.t67 VDD.t1 sg13_lv_pmos ad=1.33p pd=7.38u as=1.33p ps=7.38u w=7u l=0.7u
X188 a_n2002_n4396# a_n6543_n10895# VDD.t972 VDD.t0 sg13_lv_pmos ad=0.19p pd=1.38u as=0.19p ps=1.38u w=1u l=0.7u
X189 Von.t25 a_n10179_n275# VSS.t30 VSS.t16 sg13_lv_nmos ad=0.912p pd=5.18u as=0.912p ps=5.18u w=4.8u l=1.06u
X190 VDD.t466 a_1220_1772# Vop.t90 VDD.t1 sg13_lv_pmos ad=0.4658p pd=3.42u as=0.2603p ps=1.75u w=1.37u l=0.35u
X191 VDD.t352 a_1220_1772# Vop.t153 VDD.t1 sg13_lv_pmos ad=0.2603p pd=1.75u as=0.2603p ps=1.75u w=1.37u l=0.35u
X192 Von.t80 a_n10106_3341# VDD.t140 VDD.t1 sg13_lv_pmos ad=0.2603p pd=1.75u as=0.2603p ps=1.75u w=1.37u l=0.35u
X193 VDD.t86 a_n20570_n9414# VOUTN.t22 VSS.t141 sg13_lv_nmos ad=3.4p pd=20.68u as=3.4p ps=20.68u w=10u l=0.15u
X194 a_n5006_n3441# a_n6543_n10895# VDD.t940 VDD.t0 sg13_lv_pmos ad=0.19p pd=1.38u as=0.19p ps=1.38u w=1u l=0.7u
X195 a_n3162_51# CMFBin.t12 VSS.t219 VSS.t220 sg13_lv_nmos ad=0.6327p pd=3.71u as=0.6327p ps=3.71u w=3.33u l=0.2u
X196 VDD.t544 a_1220_1772# Vop.t146 VDD.t1 sg13_lv_pmos ad=0.2603p pd=1.75u as=0.2603p ps=1.75u w=1.37u l=0.35u
X197 VDD.t749 a_n6543_n10895# a_n2002_n4396# VDD.t0 sg13_lv_pmos ad=0.19p pd=1.38u as=0.19p ps=1.38u w=1u l=0.7u
X198 VDD.t735 a_n6543_n10895# a_n2002_n4396# VDD.t0 sg13_lv_pmos ad=0.19p pd=1.38u as=0.19p ps=1.38u w=1u l=0.7u
X199 Von.t4 a_n10179_n275# VSS.t56 VSS.t22 sg13_lv_nmos ad=0.912p pd=5.18u as=0.912p ps=5.18u w=4.8u l=1.06u
X200 a_n5006_n3441# Von.t158 CMFBout.t28 VDD.t0 sg13_lv_pmos ad=0.24415p pd=1.665u as=0.24415p ps=1.665u w=1.285u l=0.35u
X201 VDD.t386 a_1220_1772# Vop.t108 VDD.t1 sg13_lv_pmos ad=0.4658p pd=3.42u as=0.2603p ps=1.75u w=1.37u l=0.35u
X202 VDD.t650 a_n14155_n5285# a_n14155_n5285# VDD.t642 sg13_lv_pmos ad=3.4p pd=20.68u as=1.9p ps=10.38u w=10u l=1u
X203 a_881_4136# a_n9221_n275# a_1220_1772# VDD.t1 sg13_lv_pmos ad=0.7695p pd=4.43u as=0.7695p ps=4.43u w=4.05u l=0.5u
X204 Von.t41 a_n10106_3341# VDD.t235 VDD.t1 sg13_lv_pmos ad=0.2603p pd=1.75u as=0.4658p ps=3.42u w=1.37u l=0.35u
X205 Von.t45 a_n10106_3341# VDD.t276 VDD.t1 sg13_lv_pmos ad=0.2603p pd=1.75u as=0.2603p ps=1.75u w=1.37u l=0.35u
X206 a_n2002_n4396# Vop.t158 CMFBout.t14 VDD.t0 sg13_lv_pmos ad=0.24415p pd=1.665u as=0.24415p ps=1.665u w=1.285u l=0.35u
X207 VSS.t189 CMFBin.t22 a_n3162_51# VSS.t188 sg13_lv_nmos ad=0.6327p pd=3.71u as=0.6327p ps=3.71u w=3.33u l=0.2u
X208 Von.t39 a_n10106_3341# VDD.t248 VDD.t1 sg13_lv_pmos ad=0.2603p pd=1.75u as=0.2603p ps=1.75u w=1.37u l=0.35u
X209 a_n10106_3341# a_n9221_n275# a_n3381_1772# VDD.t1 sg13_lv_pmos ad=0.7695p pd=4.43u as=0.7695p ps=4.43u w=4.05u l=0.5u
X210 Vop.t120 a_1220_1772# VDD.t418 VDD.t1 sg13_lv_pmos ad=0.2603p pd=1.75u as=0.2603p ps=1.75u w=1.37u l=0.35u
X211 VDD.t514 a_1220_1772# Vop.t56 VDD.t1 sg13_lv_pmos ad=0.2603p pd=1.75u as=0.2603p ps=1.75u w=1.37u l=0.35u
X212 a_36_n4396# VREF.t0 a_n5006_n3441# VDD.t0 sg13_lv_pmos ad=0.24415p pd=1.665u as=0.24415p ps=1.665u w=1.285u l=0.35u
X213 a_286_1773# a_n8929_2739# a_1220_1772# VSS.t329 sg13_lv_nmos ad=0.361p pd=2.28u as=0.361p ps=2.28u w=1.9u l=0.16u
X214 Vop.t53 a_1220_1772# VDD.t494 VDD.t1 sg13_lv_pmos ad=0.2603p pd=1.75u as=0.2603p ps=1.75u w=1.37u l=0.35u
X215 a_881_4136# a_n9221_n275# a_1220_1772# VDD.t1 sg13_lv_pmos ad=0.7695p pd=4.43u as=0.7695p ps=4.43u w=4.05u l=0.5u
X216 VDD.t458 a_1220_1772# Vop.t141 VDD.t1 sg13_lv_pmos ad=0.2603p pd=1.75u as=0.2603p ps=1.75u w=1.37u l=0.35u
X217 VDD.t298 a_n10106_3341# Von.t134 VDD.t1 sg13_lv_pmos ad=0.2603p pd=1.75u as=0.2603p ps=1.75u w=1.37u l=0.35u
X218 a_n5006_n3441# VREF.t0 a_36_n4396# VDD.t0 sg13_lv_pmos ad=0.24415p pd=1.665u as=0.24415p ps=1.665u w=1.285u l=0.35u
X219 a_1220_1772# a_n9221_n275# a_881_4136# VDD.t1 sg13_lv_pmos ad=0.7695p pd=4.43u as=0.7695p ps=4.43u w=4.05u l=0.5u
X220 a_n10106_3341# a_n9221_n275# a_n3381_1772# VDD.t1 sg13_lv_pmos ad=0.7695p pd=4.43u as=0.7695p ps=4.43u w=4.05u l=0.5u
X221 Von.t146 a_n10106_3341# VDD.t202 VDD.t1 sg13_lv_pmos ad=0.2603p pd=1.75u as=0.2603p ps=1.75u w=1.37u l=0.35u
X222 VDD.t970 a_n6543_n10895# a_n2002_n4396# VDD.t0 sg13_lv_pmos ad=0.19p pd=1.38u as=0.19p ps=1.38u w=1u l=0.7u
X223 VOUTP.t0 a_13228_n9920# VDD.t609 VSS.t171 sg13_lv_nmos ad=3.4p pd=20.68u as=3.4p ps=20.68u w=10u l=0.15u
X224 VDD.t807 a_n6543_n10895# a_n5006_n3441# VDD.t0 sg13_lv_pmos ad=0.19p pd=1.38u as=0.19p ps=1.38u w=1u l=0.7u
X225 VSS.t295 CMFBout.t30 CMFBout.t32 VSS.t294 sg13_lv_nmos ad=0.6327p pd=3.71u as=0.6327p ps=3.71u w=3.33u l=0.2u
X226 a_n3162_51# CMFBin.t5 VSS.t240 VSS.t241 sg13_lv_nmos ad=0.6327p pd=3.71u as=0.6327p ps=3.71u w=3.33u l=0.2u
X227 a_n3381_1772# a_n9221_n275# a_n10106_3341# VDD.t1 sg13_lv_pmos ad=0.7695p pd=4.43u as=0.7695p ps=4.43u w=4.05u l=0.5u
X228 VDD.t154 a_n10106_3341# Von.t110 VDD.t1 sg13_lv_pmos ad=0.4658p pd=3.42u as=0.2603p ps=1.75u w=1.37u l=0.35u
X229 Von.t83 a_n10106_3341# VDD.t185 VDD.t1 sg13_lv_pmos ad=0.2603p pd=1.75u as=0.4658p ps=3.42u w=1.37u l=0.35u
X230 Vop.t24 a_n10179_n275# VSS.t89 VSS.t9 sg13_lv_nmos ad=0.912p pd=5.18u as=0.912p ps=5.18u w=4.8u l=1.06u
X231 a_n2002_n4396# a_n6543_n10895# VDD.t925 VDD.t0 sg13_lv_pmos ad=0.19p pd=1.38u as=0.19p ps=1.38u w=1u l=0.7u
X232 Von.t64 a_n10106_3341# VDD.t318 VDD.t1 sg13_lv_pmos ad=0.2603p pd=1.75u as=0.2603p ps=1.75u w=1.37u l=0.35u
X233 a_n2002_n4396# a_n6543_n10895# VDD.t869 VDD.t0 sg13_lv_pmos ad=0.19p pd=1.38u as=0.19p ps=1.38u w=1u l=0.7u
X234 a_286_1773# a_n8929_2739# a_1220_1772# VSS.t333 sg13_lv_nmos ad=0.646p pd=4.48u as=0.361p ps=2.28u w=1.9u l=0.16u
X235 Vop.t101 a_1220_1772# VDD.t444 VDD.t1 sg13_lv_pmos ad=0.2603p pd=1.75u as=0.2603p ps=1.75u w=1.37u l=0.35u
X236 a_n5006_n3441# a_n6543_n10895# VDD.t892 VDD.t0 sg13_lv_pmos ad=0.19p pd=1.38u as=0.19p ps=1.38u w=1u l=0.7u
X237 VDD.t550 a_1220_1772# Vop.t69 VDD.t1 sg13_lv_pmos ad=0.2603p pd=1.75u as=0.2603p ps=1.75u w=1.37u l=0.35u
X238 a_n2002_n4396# a_n6543_n10895# VDD.t962 VDD.t0 sg13_lv_pmos ad=0.19p pd=1.38u as=0.19p ps=1.38u w=1u l=0.7u
X239 VSS.t268 a_n13845_n10915# a_n14528_n9920# VSS.t271 sg13_lv_nmos ad=0.57p pd=3.38u as=1.02p ps=6.68u w=3u l=1u
X240 VDD.t276 a_n10106_3341# Von.t44 VDD.t1 sg13_lv_pmos ad=0.2603p pd=1.75u as=0.2603p ps=1.75u w=1.37u l=0.35u
X241 a_36_n4396# VREF.t0 a_n2002_n4396# VDD.t0 sg13_lv_pmos ad=0.24415p pd=1.665u as=0.24415p ps=1.665u w=1.285u l=0.35u
X242 a_11652_n9920# VOUTP.t26 a_13228_n9920# VSS.t3 sg13_lv_nmos ad=1.9p pd=10.38u as=1.9p ps=10.38u w=10u l=0.5u
X243 VDD.t857 a_n6543_n10895# a_n5006_n3441# VDD.t0 sg13_lv_pmos ad=0.19p pd=1.38u as=0.19p ps=1.38u w=1u l=0.7u
X244 VSS.t216 CMFBin.t13 a_n3162_51# VSS.t215 sg13_lv_nmos ad=0.6327p pd=3.71u as=0.6327p ps=3.71u w=3.33u l=0.2u
X245 Vop.t64 a_1220_1772# VDD.t477 VDD.t1 sg13_lv_pmos ad=0.2603p pd=1.75u as=0.4658p ps=3.42u w=1.37u l=0.35u
X246 VDD.t248 a_n10106_3341# Von.t38 VDD.t1 sg13_lv_pmos ad=0.2603p pd=1.75u as=0.2603p ps=1.75u w=1.37u l=0.35u
X247 a_n14155_n5285# a_n14155_n5285# VDD.t646 VDD.t642 sg13_lv_pmos ad=1.9p pd=10.38u as=1.9p ps=10.38u w=10u l=1u
X248 a_881_4136# a_n10013_2465# VDD.t64 VDD.t1 sg13_lv_pmos ad=1.33p pd=7.38u as=2.38p ps=14.68u w=7u l=0.7u
X249 VDD.t340 a_n10106_3341# Von.t140 VDD.t1 sg13_lv_pmos ad=0.2603p pd=1.75u as=0.2603p ps=1.75u w=1.37u l=0.35u
X250 a_n1828_1772# a_n8929_2739# a_n10106_3341# VSS.t323 sg13_lv_nmos ad=0.361p pd=2.28u as=0.361p ps=2.28u w=1.9u l=0.16u
X251 VDD.t312 a_n10106_3341# Von.t121 VDD.t1 sg13_lv_pmos ad=0.2603p pd=1.75u as=0.2603p ps=1.75u w=1.37u l=0.35u
X252 VDD.t950 a_n6543_n10895# a_n5006_n3441# VDD.t0 sg13_lv_pmos ad=0.19p pd=1.38u as=0.19p ps=1.38u w=1u l=0.7u
X253 VDD.t761 a_n6543_n10895# a_n5006_n3441# VDD.t0 sg13_lv_pmos ad=0.19p pd=1.38u as=0.19p ps=1.38u w=1u l=0.7u
X254 Von.t35 a_n10106_3341# VDD.t272 VDD.t1 sg13_lv_pmos ad=0.2603p pd=1.75u as=0.2603p ps=1.75u w=1.37u l=0.35u
X255 a_n2002_n4396# a_n6543_n10895# VDD.t739 VDD.t0 sg13_lv_pmos ad=0.19p pd=1.38u as=0.19p ps=1.38u w=1u l=0.7u
X256 Vop.t27 a_n10179_n275# VSS.t115 VSS.t9 sg13_lv_nmos ad=1.632p pd=10.28u as=0.912p ps=5.18u w=4.8u l=1.06u
X257 a_881_4136# a_n9221_n275# a_1220_1772# VDD.t1 sg13_lv_pmos ad=0.7695p pd=4.43u as=0.7695p ps=4.43u w=4.05u l=0.5u
X258 VDD.t486 a_1220_1772# Vop.t151 VDD.t1 sg13_lv_pmos ad=0.4658p pd=3.42u as=0.2603p ps=1.75u w=1.37u l=0.35u
X259 VDD.t224 a_n10106_3341# Von.t107 VDD.t1 sg13_lv_pmos ad=0.4658p pd=3.42u as=0.2603p ps=1.75u w=1.37u l=0.35u
X260 Vop.t156 VPout.t1 VSS.t336 rppd l=19u w=0.6u
X261 a_n10106_3341# a_n9221_n275# a_n3381_1772# VDD.t1 sg13_lv_pmos ad=0.7695p pd=4.43u as=0.7695p ps=4.43u w=4.05u l=0.5u
X262 VDD.t130 a_n10106_3341# Von.t96 VDD.t1 sg13_lv_pmos ad=0.2603p pd=1.75u as=0.2603p ps=1.75u w=1.37u l=0.35u
X263 a_1220_1772# a_n8929_2739# a_286_1773# VSS.t328 sg13_lv_nmos ad=0.361p pd=2.28u as=0.646p ps=4.48u w=1.9u l=0.16u
X264 VDD.t786 a_n6543_n10895# a_n2002_n4396# VDD.t0 sg13_lv_pmos ad=0.19p pd=1.38u as=0.19p ps=1.38u w=1u l=0.7u
X265 a_n3162_51# CMFBin.t14 VSS.t213 VSS.t214 sg13_lv_nmos ad=0.6327p pd=3.71u as=0.6327p ps=3.71u w=3.33u l=0.2u
X266 a_n2002_n4396# a_n6543_n10895# VDD.t887 VDD.t0 sg13_lv_pmos ad=0.19p pd=1.38u as=0.19p ps=1.38u w=1u l=0.7u
X267 a_n5006_n3441# a_n6543_n10895# VDD.t652 VDD.t0 sg13_lv_pmos ad=0.19p pd=1.38u as=0.19p ps=1.38u w=1u l=0.7u
X268 a_n3381_1772# a_n10013_2465# VDD.t21 VDD.t1 sg13_lv_pmos ad=1.33p pd=7.38u as=1.33p ps=7.38u w=7u l=0.7u
X269 VSS.t80 a_n10179_n275# Vop.t2 VSS.t9 sg13_lv_nmos ad=0.912p pd=5.18u as=0.912p ps=5.18u w=4.8u l=1.06u
X270 VDD.t532 a_1220_1772# Vop.t138 VDD.t1 sg13_lv_pmos ad=0.2603p pd=1.75u as=0.2603p ps=1.75u w=1.37u l=0.35u
X271 VDD.t500 a_1220_1772# Vop.t59 VDD.t1 sg13_lv_pmos ad=0.2603p pd=1.75u as=0.2603p ps=1.75u w=1.37u l=0.35u
X272 VDD.t922 a_n6543_n10895# a_n2002_n4396# VDD.t0 sg13_lv_pmos ad=0.19p pd=1.38u as=0.19p ps=1.38u w=1u l=0.7u
X273 Von.t134 a_n10106_3341# VDD.t296 VDD.t1 sg13_lv_pmos ad=0.2603p pd=1.75u as=0.2603p ps=1.75u w=1.37u l=0.35u
X274 VDD.t318 a_n10106_3341# Von.t63 VDD.t1 sg13_lv_pmos ad=0.2603p pd=1.75u as=0.2603p ps=1.75u w=1.37u l=0.35u
X275 a_n3162_51# VNin.t0 a_286_1773# VSS.t147 sg13_lv_nmos ad=0.374p pd=2.88u as=0.209p ps=1.48u w=1.1u l=0.15u
X276 VSS.t348 a_36_n4396# a_36_n4396# VSS.t347 sg13_lv_nmos ad=0.6327p pd=3.71u as=0.6327p ps=3.71u w=3.33u l=0.2u
X277 VSS.t109 a_n10179_n275# Vop.t17 VSS.t9 sg13_lv_nmos ad=0.912p pd=5.18u as=0.912p ps=5.18u w=4.8u l=1.06u
X278 Vop.t23 a_n10179_n275# VSS.t74 VSS.t61 sg13_lv_nmos ad=0.912p pd=5.18u as=1.632p ps=10.28u w=4.8u l=1.06u
X279 a_n5006_n3441# a_n6543_n10895# VDD.t815 VDD.t0 sg13_lv_pmos ad=0.19p pd=1.38u as=0.19p ps=1.38u w=1u l=0.7u
X280 Von.t10 a_n10179_n275# VSS.t41 VSS.t16 sg13_lv_nmos ad=0.912p pd=5.18u as=0.912p ps=5.18u w=4.8u l=1.06u
X281 a_11652_n9920# VOUTP.t26 a_13228_n9920# VSS.t7 sg13_lv_nmos ad=3.4p pd=20.68u as=1.9p ps=10.38u w=10u l=0.5u
X282 a_n14528_n9920# Von.t157 a_n14155_n5285# VSS.t300 sg13_lv_nmos ad=1.9p pd=10.38u as=1.9p ps=10.38u w=10u l=0.5u
X283 VDD.t478 a_1220_1772# Vop.t64 VDD.t1 sg13_lv_pmos ad=0.2603p pd=1.75u as=0.2603p ps=1.75u w=1.37u l=0.35u
X284 a_n2002_n4396# a_n6543_n10895# VDD.t914 VDD.t0 sg13_lv_pmos ad=0.19p pd=1.38u as=0.19p ps=1.38u w=1u l=0.7u
X285 a_n6543_n10895# a_n6543_n10895# VDD.t687 VDD.t0 sg13_lv_pmos ad=0.19p pd=1.38u as=0.19p ps=1.38u w=1u l=0.7u
X286 VSS.t15 a_n10179_n275# Von.t1 VSS.t14 sg13_lv_nmos ad=0.912p pd=5.18u as=0.912p ps=5.18u w=4.8u l=1.06u
X287 VDD.t737 a_n6543_n10895# a_n2002_n4396# VDD.t0 sg13_lv_pmos ad=0.19p pd=1.38u as=0.19p ps=1.38u w=1u l=0.7u
X288 a_11652_n9920# Vop.t157 a_11820_n9920# VSS.t160 sg13_lv_nmos ad=1.9p pd=10.38u as=1.9p ps=10.38u w=10u l=0.5u
X289 a_11652_n9920# Vop.t157 a_11820_n9920# VSS.t162 sg13_lv_nmos ad=1.9p pd=10.38u as=1.9p ps=10.38u w=10u l=0.5u
X290 VDD.t902 a_n6543_n10895# a_n5006_n3441# VDD.t0 sg13_lv_pmos ad=0.19p pd=1.38u as=0.19p ps=1.38u w=1u l=0.7u
X291 Von.t91 a_n10106_3341# VDD.t205 VDD.t1 sg13_lv_pmos ad=0.2603p pd=1.75u as=0.4658p ps=3.42u w=1.37u l=0.35u
X292 a_n1828_1772# VPin.t0 a_n3162_51# VSS.t149 sg13_lv_nmos ad=0.209p pd=1.48u as=0.374p ps=2.88u w=1.1u l=0.15u
X293 VDD.t570 a_1220_1772# Vop.t40 VDD.t1 sg13_lv_pmos ad=0.2603p pd=1.75u as=0.2603p ps=1.75u w=1.37u l=0.35u
X294 Von.t38 a_n10106_3341# VDD.t246 VDD.t1 sg13_lv_pmos ad=0.2603p pd=1.75u as=0.2603p ps=1.75u w=1.37u l=0.35u
X295 a_n2002_n4396# Vop.t158 CMFBout.t2 VDD.t0 sg13_lv_pmos ad=0.24415p pd=1.665u as=0.24415p ps=1.665u w=1.285u l=0.35u
X296 a_n10106_3341# a_n8929_2739# a_n1828_1772# VSS.t324 sg13_lv_nmos ad=0.361p pd=2.28u as=0.361p ps=2.28u w=1.9u l=0.16u
X297 a_n3162_51# CMFBin.t26 VSS.t177 VSS.t178 sg13_lv_nmos ad=0.6327p pd=3.71u as=0.6327p ps=3.71u w=3.33u l=0.2u
X298 a_n3162_51# CMFBin.t6 VSS.t237 VSS.t238 sg13_lv_nmos ad=0.6327p pd=3.71u as=0.6327p ps=3.71u w=3.33u l=0.2u
X299 Von.t7 a_n10179_n275# VSS.t24 VSS.t25 sg13_lv_nmos ad=0.912p pd=5.18u as=0.912p ps=5.18u w=4.8u l=1.06u
X300 VDD.t885 a_n6543_n10895# a_n2002_n4396# VDD.t0 sg13_lv_pmos ad=0.19p pd=1.38u as=0.19p ps=1.38u w=1u l=0.7u
X301 Von.t140 a_n10106_3341# VDD.t338 VDD.t1 sg13_lv_pmos ad=0.2603p pd=1.75u as=0.2603p ps=1.75u w=1.37u l=0.35u
X302 a_n5006_n3441# a_n6543_n10895# VDD.t958 VDD.t0 sg13_lv_pmos ad=0.19p pd=1.38u as=0.19p ps=1.38u w=1u l=0.7u
X303 a_n3162_51# VNin.t0 a_286_1773# VSS.t145 sg13_lv_nmos ad=0.209p pd=1.48u as=0.209p ps=1.48u w=1.1u l=0.15u
X304 Vop.t126 a_1220_1772# VDD.t420 VDD.t1 sg13_lv_pmos ad=0.2603p pd=1.75u as=0.2603p ps=1.75u w=1.37u l=0.35u
X305 a_n5006_n3441# a_n6543_n10895# VDD.t729 VDD.t0 sg13_lv_pmos ad=0.19p pd=1.38u as=0.19p ps=1.38u w=1u l=0.7u
X306 Vop.t133 a_1220_1772# VDD.t532 VDD.t1 sg13_lv_pmos ad=0.2603p pd=1.75u as=0.2603p ps=1.75u w=1.37u l=0.35u
X307 Vop.t113 a_1220_1772# VDD.t388 VDD.t1 sg13_lv_pmos ad=0.2603p pd=1.75u as=0.2603p ps=1.75u w=1.37u l=0.35u
X308 a_n5006_n3441# a_n6543_n10895# VDD.t769 VDD.t0 sg13_lv_pmos ad=0.19p pd=1.38u as=0.19p ps=1.38u w=1u l=0.7u
X309 VDD.t685 a_n6543_n10895# a_n6543_n10895# VDD.t0 sg13_lv_pmos ad=0.19p pd=1.38u as=0.19p ps=1.38u w=1u l=0.7u
X310 Vop.t90 a_1220_1772# VDD.t464 VDD.t1 sg13_lv_pmos ad=0.2603p pd=1.75u as=0.2603p ps=1.75u w=1.37u l=0.35u
X311 a_n2002_n4396# a_n6543_n10895# VDD.t727 VDD.t0 sg13_lv_pmos ad=0.19p pd=1.38u as=0.19p ps=1.38u w=1u l=0.7u
X312 a_n3162_51# VPin.t0 a_n1828_1772# VSS.t150 sg13_lv_nmos ad=0.209p pd=1.48u as=0.209p ps=1.48u w=1.1u l=0.15u
X313 VDD.t296 a_n10106_3341# Von.t124 VDD.t1 sg13_lv_pmos ad=0.2603p pd=1.75u as=0.2603p ps=1.75u w=1.37u l=0.35u
X314 Von.t55 a_n10106_3341# VDD.t118 VDD.t1 sg13_lv_pmos ad=0.2603p pd=1.75u as=0.2603p ps=1.75u w=1.37u l=0.35u
X315 a_n13845_n10915# a_n13845_n10915# VSS.t275 VSS.t274 sg13_lv_nmos ad=1.02p pd=6.68u as=1.02p ps=6.68u w=3u l=1u
X316 VDD.t332 a_n10106_3341# Von.t62 VDD.t1 sg13_lv_pmos ad=0.2603p pd=1.75u as=0.2603p ps=1.75u w=1.37u l=0.35u
X317 VDD.t715 a_n6543_n10895# a_n5006_n3441# VDD.t0 sg13_lv_pmos ad=0.19p pd=1.38u as=0.19p ps=1.38u w=1u l=0.7u
X318 VDD.t114 a_n10106_3341# Von.t117 VDD.t1 sg13_lv_pmos ad=0.4658p pd=3.42u as=0.2603p ps=1.75u w=1.37u l=0.35u
X319 VDD.t73 a_n20570_n9414# VOUTN.t14 VSS.t136 sg13_lv_nmos ad=3.4p pd=20.68u as=3.4p ps=20.68u w=10u l=0.15u
X320 a_n10013_2465# a_n10013_2465# VDD.t27 VDD.t1 sg13_lv_pmos ad=0.266p pd=1.78u as=0.476p ps=3.48u w=1.4u l=0.35u
X321 VDD.t108 a_n10106_3341# Von.t31 VDD.t1 sg13_lv_pmos ad=0.2603p pd=1.75u as=0.2603p ps=1.75u w=1.37u l=0.35u
X322 VDD.t244 a_n10106_3341# Von.t70 VDD.t1 sg13_lv_pmos ad=0.4658p pd=3.42u as=0.2603p ps=1.75u w=1.37u l=0.35u
X323 CMFBout.t18 Von.t158 a_n5006_n3441# VDD.t0 sg13_lv_pmos ad=0.24415p pd=1.665u as=0.24415p ps=1.665u w=1.285u l=0.35u
X324 CMFBout.t6 Vop.t158 a_n2002_n4396# VDD.t0 sg13_lv_pmos ad=0.24415p pd=1.665u as=0.24415p ps=1.665u w=1.285u l=0.35u
X325 VDD.t792 a_n6543_n10895# a_n2002_n4396# VDD.t0 sg13_lv_pmos ad=0.19p pd=1.38u as=0.19p ps=1.38u w=1u l=0.7u
X326 a_n1828_1772# VPin.t0 a_n3162_51# VSS.t151 sg13_lv_nmos ad=0.209p pd=1.48u as=0.209p ps=1.48u w=1.1u l=0.15u
X327 Von.t63 a_n10106_3341# VDD.t316 VDD.t1 sg13_lv_pmos ad=0.2603p pd=1.75u as=0.2603p ps=1.75u w=1.37u l=0.35u
X328 VSS.t56 a_n10179_n275# Von.t3 VSS.t20 sg13_lv_nmos ad=0.912p pd=5.18u as=0.912p ps=5.18u w=4.8u l=1.06u
X329 VDD.t654 a_n6543_n10895# a_n5006_n3441# VDD.t0 sg13_lv_pmos ad=0.19p pd=1.38u as=0.19p ps=1.38u w=1u l=0.7u
X330 a_n2002_n4396# a_n6543_n10895# VDD.t780 VDD.t0 sg13_lv_pmos ad=0.19p pd=1.38u as=0.19p ps=1.38u w=1u l=0.7u
X331 VDD.t552 a_1220_1772# Vop.t134 VDD.t1 sg13_lv_pmos ad=0.2603p pd=1.75u as=0.2603p ps=1.75u w=1.37u l=0.35u
X332 a_n3162_51# VNin.t0 a_286_1773# VSS.t145 sg13_lv_nmos ad=0.209p pd=1.48u as=0.209p ps=1.48u w=1.1u l=0.15u
X333 a_n3381_1772# a_n10013_2465# VDD.t5 VDD.t1 sg13_lv_pmos ad=1.33p pd=7.38u as=1.33p ps=7.38u w=7u l=0.7u
X334 Von.t100 a_n10106_3341# VDD.t160 VDD.t1 sg13_lv_pmos ad=0.2603p pd=1.75u as=0.2603p ps=1.75u w=1.37u l=0.35u
X335 VDD.t246 a_n10106_3341# Von.t73 VDD.t1 sg13_lv_pmos ad=0.2603p pd=1.75u as=0.2603p ps=1.75u w=1.37u l=0.35u
X336 Vop.t86 a_1220_1772# VDD.t447 VDD.t1 sg13_lv_pmos ad=0.2603p pd=1.75u as=0.4658p ps=3.42u w=1.37u l=0.35u
X337 Vop.t109 a_1220_1772# VDD.t370 VDD.t1 sg13_lv_pmos ad=0.2603p pd=1.75u as=0.2603p ps=1.75u w=1.37u l=0.35u
X338 Von.t52 a_n10106_3341# VDD.t98 VDD.t1 sg13_lv_pmos ad=0.2603p pd=1.75u as=0.2603p ps=1.75u w=1.37u l=0.35u
X339 VDD.t338 a_n10106_3341# Von.t138 VDD.t1 sg13_lv_pmos ad=0.2603p pd=1.75u as=0.2603p ps=1.75u w=1.37u l=0.35u
X340 a_n3721_n10895# a_n6543_n9623# a_n2373_n10895# VSS.t312 sg13_lv_nmos ad=1.14p pd=6.38u as=1.14p ps=6.38u w=6u l=6.4u
X341 VDD.t310 a_n10106_3341# Von.t120 VDD.t1 sg13_lv_pmos ad=0.2603p pd=1.75u as=0.2603p ps=1.75u w=1.37u l=0.35u
X342 a_36_n4396# VREF.t0 a_n2002_n4396# VDD.t0 sg13_lv_pmos ad=0.24415p pd=1.665u as=0.24415p ps=1.665u w=1.285u l=0.35u
X343 a_n5006_n3441# a_n6543_n10895# VDD.t910 VDD.t0 sg13_lv_pmos ad=0.19p pd=1.38u as=0.19p ps=1.38u w=1u l=0.7u
X344 a_n1828_1772# a_n8929_2739# a_n10106_3341# VSS.t325 sg13_lv_nmos ad=0.361p pd=2.28u as=0.361p ps=2.28u w=1.9u l=0.16u
X345 a_881_4136# a_n10013_2465# VDD.t53 VDD.t1 sg13_lv_pmos ad=1.33p pd=7.38u as=1.33p ps=7.38u w=7u l=0.7u
X346 VDD.t456 a_1220_1772# Vop.t143 VDD.t1 sg13_lv_pmos ad=0.4658p pd=3.42u as=0.2603p ps=1.75u w=1.37u l=0.35u
X347 VDD.t194 a_n10106_3341# Von.t94 VDD.t1 sg13_lv_pmos ad=0.4658p pd=3.42u as=0.2603p ps=1.75u w=1.37u l=0.35u
X348 a_n5006_n3441# a_n6543_n10895# VDD.t946 VDD.t0 sg13_lv_pmos ad=0.19p pd=1.38u as=0.19p ps=1.38u w=1u l=0.7u
X349 VDD.t673 a_n6543_n10895# a_n6543_n10895# VDD.t0 sg13_lv_pmos ad=0.19p pd=1.38u as=0.19p ps=1.38u w=1u l=0.7u
X350 a_n2002_n4396# a_n6543_n10895# VDD.t889 VDD.t0 sg13_lv_pmos ad=0.19p pd=1.38u as=0.19p ps=1.38u w=1u l=0.7u
X351 a_n2002_n4396# a_n6543_n10895# VDD.t875 VDD.t0 sg13_lv_pmos ad=0.19p pd=1.38u as=0.19p ps=1.38u w=1u l=0.7u
X352 a_n1828_1772# VPin.t0 a_n3162_51# VSS.t151 sg13_lv_nmos ad=0.209p pd=1.48u as=0.209p ps=1.48u w=1.1u l=0.15u
X353 a_n3162_51# VPin.t0 a_n1828_1772# VSS.t150 sg13_lv_nmos ad=0.209p pd=1.48u as=0.209p ps=1.48u w=1.1u l=0.15u
X354 VSS.t91 a_n10179_n275# Vop.t24 VSS.t9 sg13_lv_nmos ad=0.912p pd=5.18u as=0.912p ps=5.18u w=4.8u l=1.06u
X355 VDD.t534 a_1220_1772# Vop.t133 VDD.t1 sg13_lv_pmos ad=0.2603p pd=1.75u as=0.2603p ps=1.75u w=1.37u l=0.35u
X356 a_n20570_n9414# a_n14155_n5285# VDD.t644 VDD.t642 sg13_lv_pmos ad=1.9p pd=10.38u as=1.9p ps=10.38u w=10u l=1u
X357 VDD.t502 a_1220_1772# Vop.t60 VDD.t1 sg13_lv_pmos ad=0.2603p pd=1.75u as=0.2603p ps=1.75u w=1.37u l=0.35u
X358 Vop.t153 a_1220_1772# VDD.t350 VDD.t1 sg13_lv_pmos ad=0.2603p pd=1.75u as=0.2603p ps=1.75u w=1.37u l=0.35u
X359 Vop.t44 a_1220_1772# VDD.t364 VDD.t1 sg13_lv_pmos ad=0.2603p pd=1.75u as=0.2603p ps=1.75u w=1.37u l=0.35u
X360 a_n2002_n4396# a_n6543_n10895# VDD.t788 VDD.t0 sg13_lv_pmos ad=0.19p pd=1.38u as=0.19p ps=1.38u w=1u l=0.7u
X361 VDD.t590 a_1220_1772# Vop.t34 VDD.t1 sg13_lv_pmos ad=0.2603p pd=1.75u as=0.2603p ps=1.75u w=1.37u l=0.35u
X362 Von.t106 a_n10106_3341# VDD.t225 VDD.t1 sg13_lv_pmos ad=0.2603p pd=1.75u as=0.4658p ps=3.42u w=1.37u l=0.35u
X363 VDD.t891 a_n6543_n10895# a_n2002_n4396# VDD.t0 sg13_lv_pmos ad=0.34p pd=2.68u as=0.19p ps=1.38u w=1u l=0.7u
X364 VDD.t679 a_n6543_n10895# a_n6543_n10895# VDD.t0 sg13_lv_pmos ad=0.19p pd=1.38u as=0.19p ps=1.38u w=1u l=0.7u
X365 VDD.t316 a_n10106_3341# Von.t128 VDD.t1 sg13_lv_pmos ad=0.2603p pd=1.75u as=0.2603p ps=1.75u w=1.37u l=0.35u
X366 VSS.t228 CMFBin.t9 a_n3162_51# VSS.t227 sg13_lv_nmos ad=0.6327p pd=3.71u as=0.6327p ps=3.71u w=3.33u l=0.2u
X367 CMFBout.t10 Vop.t158 a_n2002_n4396# VDD.t0 sg13_lv_pmos ad=0.24415p pd=1.665u as=0.24415p ps=1.665u w=1.285u l=0.35u
X368 Vop.t139 a_1220_1772# VDD.t517 VDD.t1 sg13_lv_pmos ad=0.2603p pd=1.75u as=0.4658p ps=3.42u w=1.37u l=0.35u
X369 a_n14528_n9920# VOUTN.t26 a_n20570_n9414# VSS.t262 sg13_lv_nmos ad=1.9p pd=10.38u as=1.9p ps=10.38u w=10u l=0.5u
X370 a_n14528_n9920# Von.t157 a_n14155_n5285# VSS.t304 sg13_lv_nmos ad=1.9p pd=10.38u as=1.9p ps=10.38u w=10u l=0.5u
X371 VOUTP.t25 IB.t1 VSS.t284 VSS.t283 sg13_lv_nmos ad=1.02p pd=6.68u as=1.02p ps=6.68u w=3u l=1u
X372 a_n5006_n3441# a_n6543_n10895# VDD.t723 VDD.t0 sg13_lv_pmos ad=0.19p pd=1.38u as=0.19p ps=1.38u w=1u l=0.7u
X373 a_36_n4396# a_36_n4396# VSS.t339 VSS.t340 sg13_lv_nmos ad=0.6327p pd=3.71u as=0.6327p ps=3.71u w=3.33u l=0.2u
X374 Vop.t16 a_n10179_n275# VSS.t84 VSS.t61 sg13_lv_nmos ad=0.912p pd=5.18u as=1.632p ps=10.28u w=4.8u l=1.06u
X375 CMFBout.t29 Von.t158 a_n5006_n3441# VDD.t0 sg13_lv_pmos ad=0.24415p pd=1.665u as=0.24415p ps=1.665u w=1.285u l=0.35u
X376 a_n14528_n9920# VOUTN.t26 a_n20570_n9414# VSS.t260 sg13_lv_nmos ad=1.9p pd=10.38u as=1.9p ps=10.38u w=10u l=0.5u
X377 a_n2002_n4396# a_n6543_n10895# VDD.t825 VDD.t0 sg13_lv_pmos ad=0.19p pd=1.38u as=0.19p ps=1.38u w=1u l=0.7u
X378 a_n6543_n10895# a_n6543_n10895# VDD.t699 VDD.t0 sg13_lv_pmos ad=0.19p pd=1.38u as=0.19p ps=1.38u w=1u l=0.7u
X379 Vop.t135 a_1220_1772# VDD.t552 VDD.t1 sg13_lv_pmos ad=0.2603p pd=1.75u as=0.2603p ps=1.75u w=1.37u l=0.35u
X380 a_n3162_51# CMFBin.t25 VSS.t180 VSS.t181 sg13_lv_nmos ad=0.6327p pd=3.71u as=0.6327p ps=3.71u w=3.33u l=0.2u
X381 VDD.t63 a_n10013_2465# a_881_4136# VDD.t1 sg13_lv_pmos ad=2.38p pd=14.68u as=1.33p ps=7.38u w=7u l=0.7u
X382 a_n3162_51# CMFBin.t7 VSS.t234 VSS.t235 sg13_lv_nmos ad=0.6327p pd=3.71u as=0.6327p ps=3.71u w=3.33u l=0.2u
X383 Vop.t151 a_1220_1772# VDD.t484 VDD.t1 sg13_lv_pmos ad=0.2603p pd=1.75u as=0.2603p ps=1.75u w=1.37u l=0.35u
X384 VDD.t448 a_1220_1772# Vop.t86 VDD.t1 sg13_lv_pmos ad=0.2603p pd=1.75u as=0.2603p ps=1.75u w=1.37u l=0.35u
X385 VDD.t526 a_1220_1772# Vop.t82 VDD.t1 sg13_lv_pmos ad=0.4658p pd=3.42u as=0.2603p ps=1.75u w=1.37u l=0.35u
X386 Von.t113 a_n10106_3341# VDD.t115 VDD.t1 sg13_lv_pmos ad=0.2603p pd=1.75u as=0.4658p ps=3.42u w=1.37u l=0.35u
X387 a_11652_n9920# VOUTP.t26 a_13228_n9920# VSS.t1 sg13_lv_nmos ad=1.9p pd=10.38u as=1.9p ps=10.38u w=10u l=0.5u
X388 VDD.t813 a_n6543_n10895# a_n5006_n3441# VDD.t0 sg13_lv_pmos ad=0.19p pd=1.38u as=0.19p ps=1.38u w=1u l=0.7u
X389 a_n3721_n10895# a_n6543_n9623# a_n2373_n10895# VSS.t314 sg13_lv_nmos ad=1.14p pd=6.38u as=1.14p ps=6.38u w=6u l=6.4u
X390 a_n5006_n3441# VREF.t0 a_36_n4396# VDD.t0 sg13_lv_pmos ad=0.24415p pd=1.665u as=0.4369p ps=3.25u w=1.285u l=0.35u
X391 VOUTN.t12 a_n20570_n9414# VDD.t91 VSS.t137 sg13_lv_nmos ad=3.4p pd=20.68u as=3.4p ps=20.68u w=10u l=0.15u
X392 VDD.t572 a_1220_1772# Vop.t33 VDD.t1 sg13_lv_pmos ad=0.2603p pd=1.75u as=0.2603p ps=1.75u w=1.37u l=0.35u
X393 a_36_n4396# VREF.t0 a_n5006_n3441# VDD.t0 sg13_lv_pmos ad=0.24415p pd=1.665u as=0.24415p ps=1.665u w=1.285u l=0.35u
X394 Vop.t114 a_1220_1772# VDD.t372 VDD.t1 sg13_lv_pmos ad=0.2603p pd=1.75u as=0.2603p ps=1.75u w=1.37u l=0.35u
X395 a_n5006_n3441# a_n6543_n10895# VDD.t757 VDD.t0 sg13_lv_pmos ad=0.19p pd=1.38u as=0.19p ps=1.38u w=1u l=0.7u
X396 a_n5006_n3441# Von.t158 CMFBout.t24 VDD.t0 sg13_lv_pmos ad=0.24415p pd=1.665u as=0.24415p ps=1.665u w=1.285u l=0.35u
X397 Von.t138 a_n10106_3341# VDD.t336 VDD.t1 sg13_lv_pmos ad=0.2603p pd=1.75u as=0.2603p ps=1.75u w=1.37u l=0.35u
X398 a_n2002_n4396# Vop.t158 CMFBout.t13 VDD.t0 sg13_lv_pmos ad=0.24415p pd=1.665u as=0.24415p ps=1.665u w=1.285u l=0.35u
X399 a_n10106_3341# a_n8929_2739# a_n1828_1772# VSS.t326 sg13_lv_nmos ad=0.361p pd=2.28u as=0.361p ps=2.28u w=1.9u l=0.16u
X400 Vop.t3 a_n10179_n275# VSS.t80 VSS.t9 sg13_lv_nmos ad=0.912p pd=5.18u as=0.912p ps=5.18u w=4.8u l=1.06u
X401 Von.t120 a_n10106_3341# VDD.t308 VDD.t1 sg13_lv_pmos ad=0.2603p pd=1.75u as=0.2603p ps=1.75u w=1.37u l=0.35u
X402 a_n5006_n3441# a_n6543_n10895# VDD.t898 VDD.t0 sg13_lv_pmos ad=0.19p pd=1.38u as=0.19p ps=1.38u w=1u l=0.7u
X403 a_1220_1772# a_n9221_n275# a_881_4136# VDD.t1 sg13_lv_pmos ad=0.7695p pd=4.43u as=1.377p ps=8.78u w=4.05u l=0.5u
X404 VDD.t655 a_n6543_n10895# a_n5006_n3441# VDD.t0 sg13_lv_pmos ad=0.19p pd=1.38u as=0.19p ps=1.38u w=1u l=0.7u
X405 Vop.t155 a_1220_1772# VDD.t390 VDD.t1 sg13_lv_pmos ad=0.2603p pd=1.75u as=0.2603p ps=1.75u w=1.37u l=0.35u
X406 Von.t126 a_n10106_3341# VDD.t292 VDD.t1 sg13_lv_pmos ad=0.2603p pd=1.75u as=0.2603p ps=1.75u w=1.37u l=0.35u
X407 VDD.t94 a_n20570_n9414# VOUTN.t24 VSS.t140 sg13_lv_nmos ad=3.4p pd=20.68u as=3.4p ps=20.68u w=10u l=0.15u
X408 a_n2002_n4396# a_n6543_n10895# VDD.t842 VDD.t0 sg13_lv_pmos ad=0.19p pd=1.38u as=0.19p ps=1.38u w=1u l=0.7u
X409 Vop.t78 a_1220_1772# VDD.t502 VDD.t1 sg13_lv_pmos ad=0.2603p pd=1.75u as=0.2603p ps=1.75u w=1.37u l=0.35u
X410 CMFBout.t31 CMFBout.t30 VSS.t289 VSS.t290 sg13_lv_nmos ad=0.6327p pd=3.71u as=0.6327p ps=3.71u w=3.33u l=0.2u
X411 a_286_1773# a_n8929_2739# a_1220_1772# VSS.t329 sg13_lv_nmos ad=0.361p pd=2.28u as=0.361p ps=2.28u w=1.9u l=0.16u
X412 a_n3162_51# VPin.t0 a_n1828_1772# VSS.t152 sg13_lv_nmos ad=0.209p pd=1.48u as=0.209p ps=1.48u w=1.1u l=0.15u
X413 Von.t66 a_n10106_3341# VDD.t95 VDD.t1 sg13_lv_pmos ad=0.2603p pd=1.75u as=0.4658p ps=3.42u w=1.37u l=0.35u
X414 a_n3381_1772# a_n9221_n275# a_n10106_3341# VDD.t1 sg13_lv_pmos ad=1.377p pd=8.78u as=0.7695p ps=4.43u w=4.05u l=0.5u
X415 Von.t143 a_n10106_3341# VDD.t180 VDD.t1 sg13_lv_pmos ad=0.2603p pd=1.75u as=0.2603p ps=1.75u w=1.37u l=0.35u
X416 a_n14528_n9920# VOUTN.t26 a_n20570_n9414# VSS.t258 sg13_lv_nmos ad=1.9p pd=10.38u as=1.9p ps=10.38u w=10u l=0.5u
X417 VDD.t942 a_n6543_n10895# a_n5006_n3441# VDD.t0 sg13_lv_pmos ad=0.19p pd=1.38u as=0.19p ps=1.38u w=1u l=0.7u
X418 a_n6543_n10895# a_n6543_n10895# VDD.t667 VDD.t0 sg13_lv_pmos ad=0.19p pd=1.38u as=0.19p ps=1.38u w=1u l=0.7u
X419 a_n3162_51# VNin.t0 a_286_1773# VSS.t143 sg13_lv_nmos ad=0.209p pd=1.48u as=0.209p ps=1.48u w=1.1u l=0.15u
X420 Vop.t18 a_n10179_n275# VSS.t109 VSS.t9 sg13_lv_nmos ad=0.912p pd=5.18u as=0.912p ps=5.18u w=4.8u l=1.06u
X421 VDD.t518 a_1220_1772# Vop.t139 VDD.t1 sg13_lv_pmos ad=0.2603p pd=1.75u as=0.2603p ps=1.75u w=1.37u l=0.35u
X422 VSS.t75 a_n10179_n275# Vop.t23 VSS.t63 sg13_lv_nmos ad=0.912p pd=5.18u as=0.912p ps=5.18u w=4.8u l=1.06u
X423 VOUTN.t8 a_n20570_n9414# VDD.t70 VSS.t133 sg13_lv_nmos ad=3.4p pd=20.68u as=3.4p ps=20.68u w=10u l=0.15u
X424 a_n5006_n3441# a_n6543_n10895# VDD.t773 VDD.t0 sg13_lv_pmos ad=0.19p pd=1.38u as=0.19p ps=1.38u w=1u l=0.7u
X425 VDD.t330 a_n10106_3341# Von.t61 VDD.t1 sg13_lv_pmos ad=0.2603p pd=1.75u as=0.2603p ps=1.75u w=1.37u l=0.35u
X426 a_n2002_n4396# VREF.t0 a_36_n4396# VDD.t0 sg13_lv_pmos ad=0.24415p pd=1.665u as=0.24415p ps=1.665u w=1.285u l=0.35u
X427 Vop.t45 a_1220_1772# VDD.t352 VDD.t1 sg13_lv_pmos ad=0.2603p pd=1.75u as=0.2603p ps=1.75u w=1.37u l=0.35u
X428 Von.t43 a_n10106_3341# VDD.t262 VDD.t1 sg13_lv_pmos ad=0.2603p pd=1.75u as=0.2603p ps=1.75u w=1.37u l=0.35u
X429 VDD.t606 a_13228_n9920# VOUTP.t14 VSS.t168 sg13_lv_nmos ad=3.4p pd=20.68u as=3.4p ps=20.68u w=10u l=0.15u
X430 VSS.t335 a_n8929_2739# a_n8929_2739# VSS.t334 sg13_lv_nmos ad=0.17p pd=1.68u as=0.17p ps=1.68u w=0.5u l=0.8u
X431 a_n2002_n4396# VREF.t0 a_36_n4396# VDD.t0 sg13_lv_pmos ad=0.24415p pd=1.665u as=0.24415p ps=1.665u w=1.285u l=0.35u
X432 Von.t1 a_n10179_n275# VSS.t12 VSS.t13 sg13_lv_nmos ad=0.912p pd=5.18u as=0.912p ps=5.18u w=4.8u l=1.06u
X433 a_286_1773# a_n8929_2739# a_1220_1772# VSS.t329 sg13_lv_nmos ad=0.361p pd=2.28u as=0.361p ps=2.28u w=1.9u l=0.16u
X434 VDD.t214 a_n10106_3341# Von.t82 VDD.t1 sg13_lv_pmos ad=0.4658p pd=3.42u as=0.2603p ps=1.75u w=1.37u l=0.35u
X435 a_n5006_n3441# a_n6543_n10895# VDD.t711 VDD.t0 sg13_lv_pmos ad=0.19p pd=1.38u as=0.19p ps=1.38u w=1u l=0.7u
X436 a_11652_n9920# Vop.t157 a_11820_n9920# VSS.t158 sg13_lv_nmos ad=1.9p pd=10.38u as=1.9p ps=10.38u w=10u l=0.5u
X437 a_n14528_n9920# Von.t157 a_n14155_n5285# VSS.t302 sg13_lv_nmos ad=1.9p pd=10.38u as=1.9p ps=10.38u w=10u l=0.5u
X438 VDD.t677 a_n6543_n10895# a_n6543_n10895# VDD.t0 sg13_lv_pmos ad=0.19p pd=1.38u as=0.19p ps=1.38u w=1u l=0.7u
X439 a_n3162_51# CMFBin.t3 VSS.t246 VSS.t247 sg13_lv_nmos ad=0.6327p pd=3.71u as=0.6327p ps=3.71u w=3.33u l=0.2u
X440 VDD.t554 a_1220_1772# Vop.t135 VDD.t1 sg13_lv_pmos ad=0.2603p pd=1.75u as=0.2603p ps=1.75u w=1.37u l=0.35u
X441 a_n3381_1772# a_n10013_2465# VDD.t11 VDD.t1 sg13_lv_pmos ad=1.33p pd=7.38u as=1.33p ps=7.38u w=7u l=0.7u
X442 Vop.t31 a_1220_1772# VDD.t572 VDD.t1 sg13_lv_pmos ad=0.2603p pd=1.75u as=0.2603p ps=1.75u w=1.37u l=0.35u
X443 VSS.t24 a_n10179_n275# Von.t14 VSS.t23 sg13_lv_nmos ad=0.912p pd=5.18u as=0.912p ps=5.18u w=4.8u l=1.06u
X444 a_n3162_51# VPin.t0 a_n1828_1772# VSS.t154 sg13_lv_nmos ad=0.374p pd=2.88u as=0.209p ps=1.48u w=1.1u l=0.15u
X445 VSS.t207 CMFBin.t16 a_n3162_51# VSS.t206 sg13_lv_nmos ad=0.6327p pd=3.71u as=0.6327p ps=3.71u w=3.33u l=0.2u
X446 VDD.t336 a_n10106_3341# Von.t65 VDD.t1 sg13_lv_pmos ad=0.2603p pd=1.75u as=0.2603p ps=1.75u w=1.37u l=0.35u
X447 Von.t53 a_n10106_3341# VDD.t130 VDD.t1 sg13_lv_pmos ad=0.2603p pd=1.75u as=0.2603p ps=1.75u w=1.37u l=0.35u
X448 a_881_4136# a_n9221_n275# a_1220_1772# VDD.t1 sg13_lv_pmos ad=1.377p pd=8.78u as=0.7695p ps=4.43u w=4.05u l=0.5u
X449 VDD.t308 a_n10106_3341# Von.t127 VDD.t1 sg13_lv_pmos ad=0.2603p pd=1.75u as=0.2603p ps=1.75u w=1.37u l=0.35u
X450 CMFBout.t27 Von.t158 a_n5006_n3441# VDD.t0 sg13_lv_pmos ad=0.24415p pd=1.665u as=0.24415p ps=1.665u w=1.285u l=0.35u
X451 a_n5006_n3441# VREF.t0 a_36_n4396# VDD.t0 sg13_lv_pmos ad=0.24415p pd=1.665u as=0.24415p ps=1.665u w=1.285u l=0.35u
X452 VDD.t840 a_n6543_n10895# a_n2002_n4396# VDD.t0 sg13_lv_pmos ad=0.19p pd=1.38u as=0.19p ps=1.38u w=1u l=0.7u
X453 a_n1828_1772# a_n8929_2739# a_n10106_3341# VSS.t323 sg13_lv_nmos ad=0.361p pd=2.28u as=0.361p ps=2.28u w=1.9u l=0.16u
X454 a_n6543_n10895# a_n6543_n10895# VDD.t695 VDD.t0 sg13_lv_pmos ad=0.19p pd=1.38u as=0.19p ps=1.38u w=1u l=0.7u
X455 a_n10106_3341# a_n9221_n275# a_n3381_1772# VDD.t1 sg13_lv_pmos ad=0.7695p pd=4.43u as=1.377p ps=8.78u w=4.05u l=0.5u
X456 a_n1828_1772# a_n8929_2739# a_n10106_3341# VSS.t327 sg13_lv_nmos ad=0.646p pd=4.48u as=0.361p ps=2.28u w=1.9u l=0.16u
X457 VDD.t894 a_n6543_n10895# a_n5006_n3441# VDD.t0 sg13_lv_pmos ad=0.19p pd=1.38u as=0.19p ps=1.38u w=1u l=0.7u
X458 a_1220_1772# a_n8929_2739# a_286_1773# VSS.t328 sg13_lv_nmos ad=0.361p pd=2.28u as=0.646p ps=4.48u w=1.9u l=0.16u
X459 a_n3162_51# CMFBin.t24 VSS.t183 VSS.t184 sg13_lv_nmos ad=0.6327p pd=3.71u as=0.6327p ps=3.71u w=3.33u l=0.2u
X460 Vop.t127 a_1220_1772# VDD.t408 VDD.t1 sg13_lv_pmos ad=0.2603p pd=1.75u as=0.2603p ps=1.75u w=1.37u l=0.35u
X461 VDD.t172 a_n10106_3341# Von.t151 VDD.t1 sg13_lv_pmos ad=0.2603p pd=1.75u as=0.2603p ps=1.75u w=1.37u l=0.35u
X462 a_286_1773# VNin.t0 a_n3162_51# VSS.t142 sg13_lv_nmos ad=0.209p pd=1.48u as=0.374p ps=2.88u w=1.1u l=0.15u
X463 VDD.t504 a_1220_1772# Vop.t78 VDD.t1 sg13_lv_pmos ad=0.2603p pd=1.75u as=0.2603p ps=1.75u w=1.37u l=0.35u
X464 a_n3162_51# VNin.t0 a_286_1773# VSS.t143 sg13_lv_nmos ad=0.209p pd=1.48u as=0.209p ps=1.48u w=1.1u l=0.15u
X465 VDD.t592 a_1220_1772# Vop.t35 VDD.t1 sg13_lv_pmos ad=0.2603p pd=1.75u as=0.2603p ps=1.75u w=1.37u l=0.35u
X466 VDD.t879 a_n6543_n10895# a_n2002_n4396# VDD.t0 sg13_lv_pmos ad=0.19p pd=1.38u as=0.19p ps=1.38u w=1u l=0.7u
X467 Von.t92 a_n10106_3341# VDD.t195 VDD.t1 sg13_lv_pmos ad=0.2603p pd=1.75u as=0.4658p ps=3.42u w=1.37u l=0.35u
X468 VDD.t560 a_1220_1772# Vop.t140 VDD.t1 sg13_lv_pmos ad=0.2603p pd=1.75u as=0.2603p ps=1.75u w=1.37u l=0.35u
X469 VSS.t60 a_n10179_n275# Von.t26 VSS.t26 sg13_lv_nmos ad=1.632p pd=10.28u as=0.912p ps=5.18u w=4.8u l=1.06u
X470 a_n3162_51# VPin.t0 a_n1828_1772# VSS.t154 sg13_lv_nmos ad=0.374p pd=2.88u as=0.209p ps=1.48u w=1.1u l=0.15u
X471 Von.t61 a_n10106_3341# VDD.t328 VDD.t1 sg13_lv_pmos ad=0.2603p pd=1.75u as=0.2603p ps=1.75u w=1.37u l=0.35u
X472 VDD.t976 a_n6543_n10895# a_n2002_n4396# VDD.t0 sg13_lv_pmos ad=0.19p pd=1.38u as=0.19p ps=1.38u w=1u l=0.7u
X473 a_11652_n9920# VOUTP.t26 a_13228_n9920# VSS.t5 sg13_lv_nmos ad=1.9p pd=10.38u as=1.9p ps=10.38u w=10u l=0.5u
X474 VDD.t802 a_n6543_n10895# a_n5006_n3441# VDD.t0 sg13_lv_pmos ad=0.19p pd=1.38u as=0.19p ps=1.38u w=1u l=0.7u
X475 a_1220_1772# a_n8929_2739# a_286_1773# VSS.t328 sg13_lv_nmos ad=0.361p pd=2.28u as=0.646p ps=4.48u w=1.9u l=0.16u
X476 Vop.t143 a_1220_1772# VDD.t454 VDD.t1 sg13_lv_pmos ad=0.2603p pd=1.75u as=0.2603p ps=1.75u w=1.37u l=0.35u
X477 VDD.t707 a_n6543_n10895# a_n5006_n3441# VDD.t0 sg13_lv_pmos ad=0.19p pd=1.38u as=0.19p ps=1.38u w=1u l=0.7u
X478 a_881_4136# a_n10013_2465# VDD.t61 VDD.t1 sg13_lv_pmos ad=1.33p pd=7.38u as=1.33p ps=7.38u w=7u l=0.7u
X479 VDD.t382 a_1220_1772# Vop.t123 VDD.t1 sg13_lv_pmos ad=0.2603p pd=1.75u as=0.2603p ps=1.75u w=1.37u l=0.35u
X480 a_1220_1772# a_n9221_n275# a_881_4136# VDD.t1 sg13_lv_pmos ad=0.7695p pd=4.43u as=0.7695p ps=4.43u w=4.05u l=0.5u
X481 a_3041_6527# Vop.t30 cap_cmim l=21.4u w=21.4u
X482 VDD.t574 a_1220_1772# Vop.t31 VDD.t1 sg13_lv_pmos ad=0.2603p pd=1.75u as=0.2603p ps=1.75u w=1.37u l=0.35u
X483 VDD.t37 a_n10013_2465# a_n3381_1772# VDD.t1 sg13_lv_pmos ad=1.33p pd=7.38u as=1.33p ps=7.38u w=7u l=0.7u
X484 a_n3381_1772# a_n9221_n275# a_n10106_3341# VDD.t1 sg13_lv_pmos ad=0.7695p pd=4.43u as=0.7695p ps=4.43u w=4.05u l=0.5u
X485 VDD.t234 a_n10106_3341# Von.t76 VDD.t1 sg13_lv_pmos ad=0.4658p pd=3.42u as=0.2603p ps=1.75u w=1.37u l=0.35u
X486 a_n10106_3341# a_n8929_2739# a_n1828_1772# VSS.t324 sg13_lv_nmos ad=0.361p pd=2.28u as=0.361p ps=2.28u w=1.9u l=0.16u
X487 Von.t40 a_n10106_3341# VDD.t265 VDD.t1 sg13_lv_pmos ad=0.2603p pd=1.75u as=0.4658p ps=3.42u w=1.37u l=0.35u
X488 Vop.t10 a_n10179_n275# VSS.t91 VSS.t9 sg13_lv_nmos ad=0.912p pd=5.18u as=0.912p ps=5.18u w=4.8u l=1.06u
X489 VDD.t53 a_n10013_2465# a_881_4136# VDD.t1 sg13_lv_pmos ad=1.33p pd=7.38u as=1.33p ps=7.38u w=7u l=0.7u
X490 Von.t127 a_n10106_3341# VDD.t306 VDD.t1 sg13_lv_pmos ad=0.2603p pd=1.75u as=0.2603p ps=1.75u w=1.37u l=0.35u
X491 VOUTP.t6 a_13228_n9920# VDD.t613 VSS.t167 sg13_lv_nmos ad=3.4p pd=20.68u as=3.4p ps=20.68u w=10u l=0.15u
X492 a_n2002_n4396# a_n6543_n10895# VDD.t844 VDD.t0 sg13_lv_pmos ad=0.19p pd=1.38u as=0.19p ps=1.38u w=1u l=0.7u
X493 VSS.t98 a_n10179_n275# Von.t12 VSS.t14 sg13_lv_nmos ad=0.912p pd=5.18u as=0.912p ps=5.18u w=4.8u l=1.06u
X494 VDD.t861 a_n6543_n10895# a_n5006_n3441# VDD.t0 sg13_lv_pmos ad=0.19p pd=1.38u as=0.19p ps=1.38u w=1u l=0.7u
X495 a_n2002_n4396# a_n6543_n10895# VDD.t831 VDD.t0 sg13_lv_pmos ad=0.19p pd=1.38u as=0.19p ps=1.38u w=1u l=0.7u
X496 a_n5006_n3441# Von.t158 CMFBout.t21 VDD.t0 sg13_lv_pmos ad=0.24415p pd=1.665u as=0.24415p ps=1.665u w=1.285u l=0.35u
X497 a_n2002_n4396# Vop.t158 CMFBout.t6 VDD.t0 sg13_lv_pmos ad=0.24415p pd=1.665u as=0.24415p ps=1.665u w=1.285u l=0.35u
X498 Vop.t37 a_1220_1772# VDD.t592 VDD.t1 sg13_lv_pmos ad=0.2603p pd=1.75u as=0.2603p ps=1.75u w=1.37u l=0.35u
X499 a_n3162_51# CMFBin.t4 VSS.t243 VSS.t244 sg13_lv_nmos ad=0.6327p pd=3.71u as=0.6327p ps=3.71u w=3.33u l=0.2u
X500 Von.t109 a_n10106_3341# VDD.t150 VDD.t1 sg13_lv_pmos ad=0.2603p pd=1.75u as=0.2603p ps=1.75u w=1.37u l=0.35u
X501 Vop.t82 a_1220_1772# VDD.t524 VDD.t1 sg13_lv_pmos ad=0.2603p pd=1.75u as=0.2603p ps=1.75u w=1.37u l=0.35u
X502 VDD.t964 a_n6543_n10895# a_n2002_n4396# VDD.t0 sg13_lv_pmos ad=0.19p pd=1.38u as=0.19p ps=1.38u w=1u l=0.7u
X503 VDD.t604 a_13228_n9920# VOUTP.t22 VSS.t174 sg13_lv_nmos ad=3.4p pd=20.68u as=3.4p ps=20.68u w=10u l=0.15u
X504 VDD.t846 a_n6543_n10895# a_n2002_n4396# VDD.t0 sg13_lv_pmos ad=0.34p pd=2.68u as=0.19p ps=1.38u w=1u l=0.7u
X505 VSS.t85 a_n10179_n275# Vop.t16 VSS.t63 sg13_lv_nmos ad=0.912p pd=5.18u as=0.912p ps=5.18u w=4.8u l=1.06u
X506 VDD.t328 a_n10106_3341# Von.t60 VDD.t1 sg13_lv_pmos ad=0.2603p pd=1.75u as=0.2603p ps=1.75u w=1.37u l=0.35u
X507 VDD.t867 a_n6543_n10895# a_n5006_n3441# VDD.t0 sg13_lv_pmos ad=0.19p pd=1.38u as=0.19p ps=1.38u w=1u l=0.7u
X508 Von.t28 a_n10179_n275# VSS.t104 VSS.t25 sg13_lv_nmos ad=0.912p pd=5.18u as=0.912p ps=5.18u w=4.8u l=1.06u
X509 a_n14528_n9920# VOUTN.t26 a_n20570_n9414# VSS.t264 sg13_lv_nmos ad=1.9p pd=10.38u as=1.9p ps=10.38u w=10u l=0.5u
X510 a_n5006_n3441# a_n6543_n10895# VDD.t923 VDD.t0 sg13_lv_pmos ad=0.19p pd=1.38u as=0.34p ps=2.68u w=1u l=0.7u
X511 a_11652_n9920# Vop.t157 a_11820_n9920# VSS.t164 sg13_lv_nmos ad=1.9p pd=10.38u as=1.9p ps=10.38u w=10u l=0.5u
X512 VDD.t665 a_n6543_n10895# a_n6543_n10895# VDD.t0 sg13_lv_pmos ad=0.19p pd=1.38u as=0.19p ps=1.38u w=1u l=0.7u
X513 a_1220_1772# a_n8929_2739# a_286_1773# VSS.t332 sg13_lv_nmos ad=0.361p pd=2.28u as=0.361p ps=2.28u w=1.9u l=0.16u
X514 a_36_n4396# VREF.t0 a_n5006_n3441# VDD.t0 sg13_lv_pmos ad=0.24415p pd=1.665u as=0.24415p ps=1.665u w=1.285u l=0.35u
X515 VDD.t929 a_n6543_n10895# a_n2002_n4396# VDD.t0 sg13_lv_pmos ad=0.19p pd=1.38u as=0.19p ps=1.38u w=1u l=0.7u
X516 VSS.t210 CMFBin.t15 a_n3162_51# VSS.t209 sg13_lv_nmos ad=0.6327p pd=3.71u as=0.6327p ps=3.71u w=3.33u l=0.2u
X517 Vop.t15 a_n10179_n275# VSS.t64 VSS.t9 sg13_lv_nmos ad=0.912p pd=5.18u as=0.912p ps=5.18u w=4.8u l=1.06u
X518 VOUTN.t7 a_n20570_n9414# VDD.t76 VSS.t139 sg13_lv_nmos ad=3.4p pd=20.68u as=3.4p ps=20.68u w=10u l=0.15u
X519 a_n2002_n4396# a_n6543_n10895# VDD.t883 VDD.t0 sg13_lv_pmos ad=0.19p pd=1.38u as=0.19p ps=1.38u w=1u l=0.7u
X520 a_n5006_n3441# VREF.t0 a_36_n4396# VDD.t0 sg13_lv_pmos ad=0.24415p pd=1.665u as=0.24415p ps=1.665u w=1.285u l=0.35u
X521 Vop.t83 a_1220_1772# VDD.t537 VDD.t1 sg13_lv_pmos ad=0.2603p pd=1.75u as=0.4658p ps=3.42u w=1.37u l=0.35u
X522 a_13228_n9920# a_11820_n9920# VDD.t634 VDD.t633 sg13_lv_pmos ad=1.9p pd=10.38u as=1.9p ps=10.38u w=10u l=1u
X523 a_n2002_n4396# a_n6543_n10895# VDD.t782 VDD.t0 sg13_lv_pmos ad=0.19p pd=1.38u as=0.19p ps=1.38u w=1u l=0.7u
X524 Vop.t99 a_1220_1772# VDD.t428 VDD.t1 sg13_lv_pmos ad=0.2603p pd=1.75u as=0.2603p ps=1.75u w=1.37u l=0.35u
X525 VDD.t580 a_1220_1772# Vop.t150 VDD.t1 sg13_lv_pmos ad=0.2603p pd=1.75u as=0.2603p ps=1.75u w=1.37u l=0.35u
X526 VDD.t546 a_1220_1772# Vop.t149 VDD.t1 sg13_lv_pmos ad=0.4658p pd=3.42u as=0.2603p ps=1.75u w=1.37u l=0.35u
X527 Von.t102 a_n10106_3341# VDD.t220 VDD.t1 sg13_lv_pmos ad=0.2603p pd=1.75u as=0.2603p ps=1.75u w=1.37u l=0.35u
X528 VDD.t306 a_n10106_3341# Von.t123 VDD.t1 sg13_lv_pmos ad=0.2603p pd=1.75u as=0.2603p ps=1.75u w=1.37u l=0.35u
X529 a_n3381_1772# a_n10013_2465# VDD.t14 VDD.t1 sg13_lv_pmos ad=1.33p pd=7.38u as=2.38p ps=14.68u w=7u l=0.7u
X530 Vop.t70 a_1220_1772# VDD.t507 VDD.t1 sg13_lv_pmos ad=0.2603p pd=1.75u as=0.4658p ps=3.42u w=1.37u l=0.35u
X531 a_n3721_n10895# a_n6543_n9623# a_n2373_n10895# VSS.t316 sg13_lv_nmos ad=1.14p pd=6.38u as=1.14p ps=6.38u w=6u l=6.4u
X532 VDD.t743 a_n6543_n10895# a_n2002_n4396# VDD.t0 sg13_lv_pmos ad=0.19p pd=1.38u as=0.19p ps=1.38u w=1u l=0.7u
X533 VSS.t115 a_n10179_n275# Vop.t21 VSS.t9 sg13_lv_nmos ad=0.912p pd=5.18u as=0.912p ps=5.18u w=4.8u l=1.06u
X534 VDD.t776 a_n6543_n10895# a_n5006_n3441# VDD.t0 sg13_lv_pmos ad=0.19p pd=1.38u as=0.19p ps=1.38u w=1u l=0.7u
X535 VSS.t12 a_n10179_n275# Von.t0 VSS.t11 sg13_lv_nmos ad=0.912p pd=5.18u as=1.632p ps=10.28u w=4.8u l=1.06u
X536 a_n1828_1772# a_n8929_2739# a_n10106_3341# VSS.t325 sg13_lv_nmos ad=0.361p pd=2.28u as=0.361p ps=2.28u w=1.9u l=0.16u
X537 a_881_4136# a_n10013_2465# VDD.t58 VDD.t1 sg13_lv_pmos ad=1.33p pd=7.38u as=2.38p ps=14.68u w=7u l=0.7u
X538 VDD.t364 a_1220_1772# Vop.t43 VDD.t1 sg13_lv_pmos ad=0.2603p pd=1.75u as=0.2603p ps=1.75u w=1.37u l=0.35u
X539 VDD.t124 a_n10106_3341# Von.t32 VDD.t1 sg13_lv_pmos ad=0.4658p pd=3.42u as=0.2603p ps=1.75u w=1.37u l=0.35u
X540 a_36_n4396# VREF.t0 a_n2002_n4396# VDD.t0 sg13_lv_pmos ad=0.24415p pd=1.665u as=0.24415p ps=1.665u w=1.285u l=0.35u
X541 a_n10106_3341# a_n8929_2739# a_n1828_1772# VSS.t322 sg13_lv_nmos ad=0.361p pd=2.28u as=0.646p ps=4.48u w=1.9u l=0.16u
X542 VDD.t780 a_n6543_n10895# a_n2002_n4396# VDD.t0 sg13_lv_pmos ad=0.19p pd=1.38u as=0.19p ps=1.38u w=1u l=0.7u
X543 VDD.t118 a_n10106_3341# Von.t57 VDD.t1 sg13_lv_pmos ad=0.2603p pd=1.75u as=0.2603p ps=1.75u w=1.37u l=0.35u
X544 VDD.t516 a_1220_1772# Vop.t93 VDD.t1 sg13_lv_pmos ad=0.4658p pd=3.42u as=0.2603p ps=1.75u w=1.37u l=0.35u
X545 a_881_4136# a_n10013_2465# VDD.t41 VDD.t1 sg13_lv_pmos ad=1.33p pd=7.38u as=1.33p ps=7.38u w=7u l=0.7u
X546 VDD.t916 a_n6543_n10895# a_n2002_n4396# VDD.t0 sg13_lv_pmos ad=0.19p pd=1.38u as=0.19p ps=1.38u w=1u l=0.7u
X547 Vop.t94 a_1220_1772# VDD.t410 VDD.t1 sg13_lv_pmos ad=0.2603p pd=1.75u as=0.2603p ps=1.75u w=1.37u l=0.35u
X548 VDD.t170 a_n10106_3341# Von.t150 VDD.t1 sg13_lv_pmos ad=0.2603p pd=1.75u as=0.2603p ps=1.75u w=1.37u l=0.35u
X549 VDD.t142 a_n10106_3341# Von.t80 VDD.t1 sg13_lv_pmos ad=0.2603p pd=1.75u as=0.2603p ps=1.75u w=1.37u l=0.35u
X550 VDD.t594 a_1220_1772# Vop.t37 VDD.t1 sg13_lv_pmos ad=0.2603p pd=1.75u as=0.2603p ps=1.75u w=1.37u l=0.35u
X551 a_n5006_n3441# a_n6543_n10895# VDD.t656 VDD.t0 sg13_lv_pmos ad=0.19p pd=1.38u as=0.34p ps=2.68u w=1u l=0.7u
X552 VDD.t562 a_1220_1772# Vop.t147 VDD.t1 sg13_lv_pmos ad=0.2603p pd=1.75u as=0.2603p ps=1.75u w=1.37u l=0.35u
X553 VDD.t538 a_1220_1772# Vop.t83 VDD.t1 sg13_lv_pmos ad=0.2603p pd=1.75u as=0.2603p ps=1.75u w=1.37u l=0.35u
X554 a_286_1773# a_n8929_2739# a_1220_1772# VSS.t331 sg13_lv_nmos ad=0.361p pd=2.28u as=0.361p ps=2.28u w=1.9u l=0.16u
X555 Von.t60 a_n10106_3341# VDD.t326 VDD.t1 sg13_lv_pmos ad=0.2603p pd=1.75u as=0.2603p ps=1.75u w=1.37u l=0.35u
X556 VDD.t19 a_n10013_2465# a_n3381_1772# VDD.t1 sg13_lv_pmos ad=2.38p pd=14.68u as=1.33p ps=7.38u w=7u l=0.7u
X557 a_1220_1772# a_n9221_n275# a_881_4136# VDD.t1 sg13_lv_pmos ad=0.7695p pd=4.43u as=0.7695p ps=4.43u w=4.05u l=0.5u
X558 Von.t14 a_n10179_n275# VSS.t21 VSS.t22 sg13_lv_nmos ad=0.912p pd=5.18u as=0.912p ps=5.18u w=4.8u l=1.06u
X559 VDD.t104 a_n10106_3341# Von.t59 VDD.t1 sg13_lv_pmos ad=0.4658p pd=3.42u as=0.2603p ps=1.75u w=1.37u l=0.35u
X560 Von.t50 a_n10106_3341# VDD.t282 VDD.t1 sg13_lv_pmos ad=0.2603p pd=1.75u as=0.2603p ps=1.75u w=1.37u l=0.35u
X561 a_n6543_n10895# a_n6543_n10895# VDD.t673 VDD.t0 sg13_lv_pmos ad=0.19p pd=1.38u as=0.19p ps=1.38u w=1u l=0.7u
X562 CMFBout.t28 Von.t158 a_n5006_n3441# VDD.t0 sg13_lv_pmos ad=0.24415p pd=1.665u as=0.24415p ps=1.665u w=1.285u l=0.35u
X563 a_n3381_1772# a_n9221_n275# a_n10106_3341# VDD.t1 sg13_lv_pmos ad=0.7695p pd=4.43u as=0.7695p ps=4.43u w=4.05u l=0.5u
X564 VDD.t98 a_n10106_3341# Von.t51 VDD.t1 sg13_lv_pmos ad=0.2603p pd=1.75u as=0.2603p ps=1.75u w=1.37u l=0.35u
X565 VDD.t731 a_n6543_n10895# a_n2002_n4396# VDD.t0 sg13_lv_pmos ad=0.19p pd=1.38u as=0.19p ps=1.38u w=1u l=0.7u
X566 VDD.t508 a_1220_1772# Vop.t70 VDD.t1 sg13_lv_pmos ad=0.2603p pd=1.75u as=0.2603p ps=1.75u w=1.37u l=0.35u
X567 a_36_n4396# a_36_n4396# VSS.t298 VSS.t337 sg13_lv_nmos ad=0.6327p pd=3.71u as=0.6327p ps=3.71u w=3.33u l=0.2u
X568 VOUTP.t9 a_13228_n9920# VDD.t617 VSS.t171 sg13_lv_nmos ad=3.4p pd=20.68u as=3.4p ps=20.68u w=10u l=0.15u
X569 a_n5006_n3441# a_n6543_n10895# VDD.t651 VDD.t0 sg13_lv_pmos ad=0.19p pd=1.38u as=0.34p ps=2.68u w=1u l=0.7u
X570 VDD.t204 a_n10106_3341# Von.t146 VDD.t1 sg13_lv_pmos ad=0.4658p pd=3.42u as=0.2603p ps=1.75u w=1.37u l=0.35u
X571 Vop.t115 a_1220_1772# VDD.t374 VDD.t1 sg13_lv_pmos ad=0.2603p pd=1.75u as=0.2603p ps=1.75u w=1.37u l=0.35u
X572 a_36_n4396# VREF.t0 a_n5006_n3441# VDD.t0 sg13_lv_pmos ad=0.24415p pd=1.665u as=0.24415p ps=1.665u w=1.285u l=0.35u
X573 a_n10106_3341# a_n8929_2739# a_n1828_1772# VSS.t326 sg13_lv_nmos ad=0.361p pd=2.28u as=0.361p ps=2.28u w=1.9u l=0.16u
X574 Von.t3 a_n10179_n275# VSS.t54 VSS.t19 sg13_lv_nmos ad=0.912p pd=5.18u as=0.912p ps=5.18u w=4.8u l=1.06u
X575 VDD.t767 a_n6543_n10895# a_n5006_n3441# VDD.t0 sg13_lv_pmos ad=0.19p pd=1.38u as=0.19p ps=1.38u w=1u l=0.7u
X576 a_11820_n9920# a_11820_n9920# VDD.t637 VDD.t633 sg13_lv_pmos ad=1.9p pd=10.38u as=1.9p ps=10.38u w=10u l=1u
X577 a_n3162_51# CMFBin.t23 VSS.t186 VSS.t187 sg13_lv_nmos ad=0.6327p pd=3.71u as=0.6327p ps=3.71u w=3.33u l=0.2u
X578 VOUTN.t9 a_n20570_n9414# VDD.t72 VSS.t135 sg13_lv_nmos ad=3.4p pd=20.68u as=3.4p ps=20.68u w=10u l=0.15u
X579 Vop.t148 a_1220_1772# VDD.t562 VDD.t1 sg13_lv_pmos ad=0.2603p pd=1.75u as=0.2603p ps=1.75u w=1.37u l=0.35u
X580 a_11652_n9920# VOUTP.t26 a_13228_n9920# VSS.t3 sg13_lv_nmos ad=1.9p pd=10.38u as=1.9p ps=10.38u w=10u l=0.5u
X581 a_n2002_n4396# Vop.t158 CMFBout.t9 VDD.t0 sg13_lv_pmos ad=0.24415p pd=1.665u as=0.24415p ps=1.665u w=1.285u l=0.35u
X582 a_n5006_n3441# a_n6543_n10895# VDD.t857 VDD.t0 sg13_lv_pmos ad=0.19p pd=1.38u as=0.19p ps=1.38u w=1u l=0.7u
X583 VSS.t255 CMFBin.t0 a_n3162_51# VSS.t254 sg13_lv_nmos ad=0.6327p pd=3.71u as=0.6327p ps=3.71u w=3.33u l=0.2u
X584 VDD.t835 a_n6543_n10895# a_n2002_n4396# VDD.t0 sg13_lv_pmos ad=0.19p pd=1.38u as=0.19p ps=1.38u w=1u l=0.7u
X585 a_1220_1772# a_n9221_n275# a_881_4136# VDD.t1 sg13_lv_pmos ad=0.7695p pd=4.43u as=0.7695p ps=4.43u w=4.05u l=0.5u
X586 Von.t69 a_n10106_3341# VDD.t240 VDD.t1 sg13_lv_pmos ad=0.2603p pd=1.75u as=0.2603p ps=1.75u w=1.37u l=0.35u
X587 VDD.t326 a_n10106_3341# Von.t137 VDD.t1 sg13_lv_pmos ad=0.2603p pd=1.75u as=0.2603p ps=1.75u w=1.37u l=0.35u
X588 Von.t150 a_n10106_3341# VDD.t168 VDD.t1 sg13_lv_pmos ad=0.2603p pd=1.75u as=0.2603p ps=1.75u w=1.37u l=0.35u
X589 a_n5006_n3441# a_n6543_n10895# VDD.t950 VDD.t0 sg13_lv_pmos ad=0.19p pd=1.38u as=0.19p ps=1.38u w=1u l=0.7u
X590 VDD.t773 a_n6543_n10895# a_n5006_n3441# VDD.t0 sg13_lv_pmos ad=0.19p pd=1.38u as=0.19p ps=1.38u w=1u l=0.7u
X591 a_n3381_1772# a_n9221_n275# a_n10106_3341# VDD.t1 sg13_lv_pmos ad=0.7695p pd=4.43u as=0.7695p ps=4.43u w=4.05u l=0.5u
X592 a_1220_1772# a_n8929_2739# a_286_1773# VSS.t330 sg13_lv_nmos ad=0.361p pd=2.28u as=0.361p ps=2.28u w=1.9u l=0.16u
X593 VDD.t75 a_n20570_n9414# VOUTN.t15 VSS.t138 sg13_lv_nmos ad=3.4p pd=20.68u as=3.4p ps=20.68u w=10u l=0.15u
X594 a_n2002_n4396# Vop.t158 CMFBout.t8 VDD.t0 sg13_lv_pmos ad=0.24415p pd=1.665u as=0.24415p ps=1.665u w=1.285u l=0.35u
X595 VSS.t292 CMFBout.t30 CMFBout.t31 VSS.t291 sg13_lv_nmos ad=0.6327p pd=3.71u as=0.6327p ps=3.71u w=3.33u l=0.2u
X596 a_n2002_n4396# a_n6543_n10895# VDD.t794 VDD.t0 sg13_lv_pmos ad=0.19p pd=1.38u as=0.19p ps=1.38u w=1u l=0.7u
X597 Vop.t46 a_1220_1772# VDD.t354 VDD.t1 sg13_lv_pmos ad=0.2603p pd=1.75u as=0.2603p ps=1.75u w=1.37u l=0.35u
X598 a_n2002_n4396# VREF.t0 a_36_n4396# VDD.t0 sg13_lv_pmos ad=0.24415p pd=1.665u as=0.24415p ps=1.665u w=1.285u l=0.35u
X599 VDD.t274 a_n10106_3341# Von.t35 VDD.t1 sg13_lv_pmos ad=0.4658p pd=3.42u as=0.2603p ps=1.75u w=1.37u l=0.35u
X600 VDD.t887 a_n6543_n10895# a_n2002_n4396# VDD.t0 sg13_lv_pmos ad=0.19p pd=1.38u as=0.19p ps=1.38u w=1u l=0.7u
X601 Vop.t100 a_1220_1772# VDD.t430 VDD.t1 sg13_lv_pmos ad=0.2603p pd=1.75u as=0.2603p ps=1.75u w=1.37u l=0.35u
X602 VDD.t873 a_n6543_n10895# a_n2002_n4396# VDD.t0 sg13_lv_pmos ad=0.19p pd=1.38u as=0.19p ps=1.38u w=1u l=0.7u
X603 Vop.t29 a_n10179_n275# VSS.t72 VSS.t9 sg13_lv_nmos ad=1.632p pd=10.28u as=0.912p ps=5.18u w=4.8u l=1.06u
X604 Vop.t117 a_1220_1772# VDD.t398 VDD.t1 sg13_lv_pmos ad=0.2603p pd=1.75u as=0.2603p ps=1.75u w=1.37u l=0.35u
X605 CMFBout.t24 Von.t158 a_n5006_n3441# VDD.t0 sg13_lv_pmos ad=0.24415p pd=1.665u as=0.24415p ps=1.665u w=1.285u l=0.35u
X606 CMFBout.t13 Vop.t158 a_n2002_n4396# VDD.t0 sg13_lv_pmos ad=0.24415p pd=1.665u as=0.24415p ps=1.665u w=1.285u l=0.35u
X607 VDD.t984 a_n6543_n10895# a_n2002_n4396# VDD.t0 sg13_lv_pmos ad=0.19p pd=1.38u as=0.19p ps=1.38u w=1u l=0.7u
X608 VDD.t582 a_1220_1772# Vop.t129 VDD.t1 sg13_lv_pmos ad=0.2603p pd=1.75u as=0.2603p ps=1.75u w=1.37u l=0.35u
X609 Von.t12 a_n10179_n275# VSS.t96 VSS.t13 sg13_lv_nmos ad=0.912p pd=5.18u as=0.912p ps=5.18u w=4.8u l=1.06u
X610 Von.t93 a_n10106_3341# VDD.t190 VDD.t1 sg13_lv_pmos ad=0.2603p pd=1.75u as=0.2603p ps=1.75u w=1.37u l=0.35u
X611 VDD.t15 a_n10013_2465# a_n3381_1772# VDD.t1 sg13_lv_pmos ad=1.33p pd=7.38u as=1.33p ps=7.38u w=7u l=0.7u
X612 Von.t96 a_n10106_3341# VDD.t128 VDD.t1 sg13_lv_pmos ad=0.2603p pd=1.75u as=0.2603p ps=1.75u w=1.37u l=0.35u
X613 VDD.t817 a_n6543_n10895# a_n5006_n3441# VDD.t0 sg13_lv_pmos ad=0.19p pd=1.38u as=0.19p ps=1.38u w=1u l=0.7u
X614 Von.t122 a_n10106_3341# VDD.t302 VDD.t1 sg13_lv_pmos ad=0.2603p pd=1.75u as=0.2603p ps=1.75u w=1.37u l=0.35u
X615 a_n1828_1772# a_n8929_2739# a_n10106_3341# VSS.t327 sg13_lv_nmos ad=0.646p pd=4.48u as=0.361p ps=2.28u w=1.9u l=0.16u
X616 a_n14528_n9920# Von.t157 a_n14155_n5285# VSS.t300 sg13_lv_nmos ad=1.9p pd=10.38u as=1.9p ps=10.38u w=10u l=0.5u
X617 VSS.t104 a_n10179_n275# Von.t20 VSS.t23 sg13_lv_nmos ad=0.912p pd=5.18u as=0.912p ps=5.18u w=4.8u l=1.06u
X618 Von.t132 a_n10106_3341# VDD.t285 VDD.t1 sg13_lv_pmos ad=0.2603p pd=1.75u as=0.4658p ps=3.42u w=1.37u l=0.35u
X619 a_881_4136# a_n9221_n275# a_1220_1772# VDD.t1 sg13_lv_pmos ad=0.7695p pd=4.43u as=0.7695p ps=4.43u w=4.05u l=0.5u
X620 a_881_4136# a_n10013_2465# VDD.t47 VDD.t1 sg13_lv_pmos ad=1.33p pd=7.38u as=1.33p ps=7.38u w=7u l=0.7u
X621 a_36_n4396# VREF.t0 a_n2002_n4396# VDD.t0 sg13_lv_pmos ad=0.24415p pd=1.665u as=0.24415p ps=1.665u w=1.285u l=0.35u
X622 a_13228_n9920# VOUTP.t26 a_11652_n9920# VSS.t2 sg13_lv_nmos ad=1.9p pd=10.38u as=1.9p ps=10.38u w=10u l=0.5u
X623 VDD.t168 a_n10106_3341# Von.t149 VDD.t1 sg13_lv_pmos ad=0.2603p pd=1.75u as=0.2603p ps=1.75u w=1.37u l=0.35u
X624 a_n5006_n3441# a_n6543_n10895# VDD.t761 VDD.t0 sg13_lv_pmos ad=0.19p pd=1.38u as=0.19p ps=1.38u w=1u l=0.7u
X625 VSS.t66 a_n10179_n275# Vop.t15 VSS.t9 sg13_lv_nmos ad=0.912p pd=5.18u as=0.912p ps=5.18u w=4.8u l=1.06u
X626 VDD.t140 a_n10106_3341# Von.t116 VDD.t1 sg13_lv_pmos ad=0.2603p pd=1.75u as=0.2603p ps=1.75u w=1.37u l=0.35u
X627 VDD.t823 a_n6543_n10895# a_n5006_n3441# VDD.t0 sg13_lv_pmos ad=0.19p pd=1.38u as=0.19p ps=1.38u w=1u l=0.7u
X628 a_11652_n9920# Vop.t157 a_11820_n9920# VSS.t160 sg13_lv_nmos ad=1.9p pd=10.38u as=1.9p ps=10.38u w=10u l=0.5u
X629 a_n10106_3341# a_n9221_n275# a_n3381_1772# VDD.t1 sg13_lv_pmos ad=0.7695p pd=4.43u as=0.7695p ps=4.43u w=4.05u l=0.5u
X630 Vop.t72 a_1220_1772# VDD.t468 VDD.t1 sg13_lv_pmos ad=0.2603p pd=1.75u as=0.2603p ps=1.75u w=1.37u l=0.35u
X631 a_n5006_n3441# a_n6543_n10895# VDD.t902 VDD.t0 sg13_lv_pmos ad=0.19p pd=1.38u as=0.19p ps=1.38u w=1u l=0.7u
X632 a_11652_n9920# Vop.t157 a_11820_n9920# VSS.t162 sg13_lv_nmos ad=1.9p pd=10.38u as=1.9p ps=10.38u w=10u l=0.5u
X633 VDD.t564 a_1220_1772# Vop.t148 VDD.t1 sg13_lv_pmos ad=0.2603p pd=1.75u as=0.2603p ps=1.75u w=1.37u l=0.35u
X634 Vop.t149 a_1220_1772# VDD.t544 VDD.t1 sg13_lv_pmos ad=0.2603p pd=1.75u as=0.2603p ps=1.75u w=1.37u l=0.35u
X635 a_n2002_n4396# a_n6543_n10895# VDD.t838 VDD.t0 sg13_lv_pmos ad=0.19p pd=1.38u as=0.19p ps=1.38u w=1u l=0.7u
X636 Vop.t123 a_1220_1772# VDD.t380 VDD.t1 sg13_lv_pmos ad=0.2603p pd=1.75u as=0.2603p ps=1.75u w=1.37u l=0.35u
X637 Von.t78 a_n10106_3341# VDD.t255 VDD.t1 sg13_lv_pmos ad=0.2603p pd=1.75u as=0.4658p ps=3.42u w=1.37u l=0.35u
X638 a_36_n4396# VREF.t0 a_n2002_n4396# VDD.t0 sg13_lv_pmos ad=0.24415p pd=1.665u as=0.24415p ps=1.665u w=1.285u l=0.35u
X639 a_36_n4396# VREF.t0 a_n2002_n4396# VDD.t0 sg13_lv_pmos ad=0.4369p pd=3.25u as=0.24415p ps=1.665u w=1.285u l=0.35u
X640 VDD.t771 a_n6543_n10895# a_n5006_n3441# VDD.t0 sg13_lv_pmos ad=0.19p pd=1.38u as=0.19p ps=1.38u w=1u l=0.7u
X641 a_n6543_n10895# a_n6543_n10895# VDD.t683 VDD.t0 sg13_lv_pmos ad=0.19p pd=1.38u as=0.19p ps=1.38u w=1u l=0.7u
X642 Von.t98 a_n10106_3341# VDD.t252 VDD.t1 sg13_lv_pmos ad=0.2603p pd=1.75u as=0.2603p ps=1.75u w=1.37u l=0.35u
X643 Vop.t130 a_1220_1772# VDD.t582 VDD.t1 sg13_lv_pmos ad=0.2603p pd=1.75u as=0.2603p ps=1.75u w=1.37u l=0.35u
X644 VDD.t420 a_1220_1772# Vop.t120 VDD.t1 sg13_lv_pmos ad=0.2603p pd=1.75u as=0.2603p ps=1.75u w=1.37u l=0.35u
X645 Vop.t93 a_1220_1772# VDD.t514 VDD.t1 sg13_lv_pmos ad=0.2603p pd=1.75u as=0.2603p ps=1.75u w=1.37u l=0.35u
X646 CMFBout.t2 Vop.t158 a_n2002_n4396# VDD.t0 sg13_lv_pmos ad=0.24415p pd=1.665u as=0.24415p ps=1.665u w=1.285u l=0.35u
X647 VDD.t671 a_n6543_n10895# a_n6543_n10895# VDD.t0 sg13_lv_pmos ad=0.19p pd=1.38u as=0.19p ps=1.38u w=1u l=0.7u
X648 VSS.t111 a_n10179_n275# Vop.t18 VSS.t9 sg13_lv_nmos ad=0.912p pd=5.18u as=0.912p ps=5.18u w=4.8u l=1.06u
X649 VDD.t937 a_n6543_n10895# a_n2002_n4396# VDD.t0 sg13_lv_pmos ad=0.19p pd=1.38u as=0.19p ps=1.38u w=1u l=0.7u
X650 CMFBout.t22 Von.t158 a_n5006_n3441# VDD.t0 sg13_lv_pmos ad=0.24415p pd=1.665u as=0.24415p ps=1.665u w=1.285u l=0.35u
X651 a_n5006_n3441# a_n6543_n10895# VDD.t715 VDD.t0 sg13_lv_pmos ad=0.19p pd=1.38u as=0.19p ps=1.38u w=1u l=0.7u
X652 a_n2002_n4396# a_n6543_n10895# VDD.t877 VDD.t0 sg13_lv_pmos ad=0.19p pd=1.38u as=0.19p ps=1.38u w=1u l=0.7u
X653 VDD.t81 a_n20570_n9414# VOUTN.t18 VSS.t136 sg13_lv_nmos ad=3.4p pd=20.68u as=3.4p ps=20.68u w=10u l=0.15u
X654 VSS.t252 CMFBin.t1 a_n3162_51# VSS.t251 sg13_lv_nmos ad=0.6327p pd=3.71u as=0.6327p ps=3.71u w=3.33u l=0.2u
X655 a_n2002_n4396# a_n6543_n10895# VDD.t790 VDD.t0 sg13_lv_pmos ad=0.19p pd=1.38u as=0.19p ps=1.38u w=1u l=0.7u
X656 Vop.t84 a_1220_1772# VDD.t527 VDD.t1 sg13_lv_pmos ad=0.2603p pd=1.75u as=0.4658p ps=3.42u w=1.37u l=0.35u
X657 a_n3162_51# VPin.t0 a_n1828_1772# VSS.t150 sg13_lv_nmos ad=0.209p pd=1.48u as=0.209p ps=1.48u w=1.1u l=0.15u
X658 a_n5006_n3441# a_n6543_n10895# VDD.t654 VDD.t0 sg13_lv_pmos ad=0.19p pd=1.38u as=0.19p ps=1.38u w=1u l=0.7u
X659 VDD.t67 a_n10013_2465# a_881_4136# VDD.t1 sg13_lv_pmos ad=1.33p pd=7.38u as=1.33p ps=7.38u w=7u l=0.7u
X660 a_n6543_n10895# a_n6543_n10895# VDD.t701 VDD.t0 sg13_lv_pmos ad=0.19p pd=1.38u as=0.19p ps=1.38u w=1u l=0.7u
X661 VDD.t602 a_13228_n9920# VOUTP.t8 VSS.t172 sg13_lv_nmos ad=3.4p pd=20.68u as=3.4p ps=20.68u w=10u l=0.15u
X662 VDD.t41 a_n10013_2465# a_881_4136# VDD.t1 sg13_lv_pmos ad=1.33p pd=7.38u as=1.33p ps=7.38u w=7u l=0.7u
X663 Von.t130 a_n10106_3341# VDD.t322 VDD.t1 sg13_lv_pmos ad=0.2603p pd=1.75u as=0.2603p ps=1.75u w=1.37u l=0.35u
X664 a_36_n4396# VREF.t0 a_n5006_n3441# VDD.t0 sg13_lv_pmos ad=0.24415p pd=1.665u as=0.24415p ps=1.665u w=1.285u l=0.35u
X665 VDD.t71 a_n20570_n9414# VOUTN.t2 VSS.t134 sg13_lv_nmos ad=3.4p pd=20.68u as=3.4p ps=20.68u w=10u l=0.15u
X666 a_11820_n9920# Vop.t157 a_11652_n9920# VSS.t159 sg13_lv_nmos ad=1.9p pd=10.38u as=1.9p ps=10.38u w=10u l=0.5u
X667 Von.t31 a_n10106_3341# VDD.t106 VDD.t1 sg13_lv_pmos ad=0.2603p pd=1.75u as=0.2603p ps=1.75u w=1.37u l=0.35u
X668 VDD.t751 a_n6543_n10895# a_n2002_n4396# VDD.t0 sg13_lv_pmos ad=0.19p pd=1.38u as=0.19p ps=1.38u w=1u l=0.7u
X669 a_n5006_n3441# Von.t158 CMFBout.t17 VDD.t0 sg13_lv_pmos ad=0.24415p pd=1.665u as=0.24415p ps=1.665u w=1.285u l=0.35u
X670 a_n2002_n4396# Vop.t158 CMFBout.t5 VDD.t0 sg13_lv_pmos ad=0.24415p pd=1.665u as=0.24415p ps=1.665u w=1.285u l=0.35u
X671 VDD.t536 a_1220_1772# Vop.t132 VDD.t1 sg13_lv_pmos ad=0.4658p pd=3.42u as=0.2603p ps=1.75u w=1.37u l=0.35u
X672 Von.t114 a_n10106_3341# VDD.t125 VDD.t1 sg13_lv_pmos ad=0.2603p pd=1.75u as=0.4658p ps=3.42u w=1.37u l=0.35u
X673 VSS.t21 a_n10179_n275# Von.t29 VSS.t20 sg13_lv_nmos ad=0.912p pd=5.18u as=0.912p ps=5.18u w=4.8u l=1.06u
X674 Von.t81 a_n10106_3341# VDD.t210 VDD.t1 sg13_lv_pmos ad=0.2603p pd=1.75u as=0.2603p ps=1.75u w=1.37u l=0.35u
X675 Von.t149 a_n10106_3341# VDD.t166 VDD.t1 sg13_lv_pmos ad=0.2603p pd=1.75u as=0.2603p ps=1.75u w=1.37u l=0.35u
X676 a_881_4136# a_n9221_n275# a_1220_1772# VDD.t1 sg13_lv_pmos ad=0.7695p pd=4.43u as=0.7695p ps=4.43u w=4.05u l=0.5u
X677 Von.t116 a_n10106_3341# VDD.t138 VDD.t1 sg13_lv_pmos ad=0.2603p pd=1.75u as=0.2603p ps=1.75u w=1.37u l=0.35u
X678 VDD.t162 a_n10106_3341# Von.t100 VDD.t1 sg13_lv_pmos ad=0.2603p pd=1.75u as=0.2603p ps=1.75u w=1.37u l=0.35u
X679 a_1220_1772# a_n8929_2739# a_286_1773# VSS.t332 sg13_lv_nmos ad=0.361p pd=2.28u as=0.361p ps=2.28u w=1.9u l=0.16u
X680 VOUTP.t3 a_13228_n9920# VDD.t599 VSS.t169 sg13_lv_nmos ad=3.4p pd=20.68u as=3.4p ps=20.68u w=10u l=0.15u
X681 a_286_1773# VNin.t0 a_n3162_51# VSS.t146 sg13_lv_nmos ad=0.209p pd=1.48u as=0.209p ps=1.48u w=1.1u l=0.15u
X682 a_n10106_3341# a_n9221_n275# a_n3381_1772# VDD.t1 sg13_lv_pmos ad=0.7695p pd=4.43u as=0.7695p ps=4.43u w=4.05u l=0.5u
X683 Vop.t107 a_1220_1772# VDD.t382 VDD.t1 sg13_lv_pmos ad=0.2603p pd=1.75u as=0.2603p ps=1.75u w=1.37u l=0.35u
X684 VDD.t948 a_n6543_n10895# a_n5006_n3441# VDD.t0 sg13_lv_pmos ad=0.19p pd=1.38u as=0.19p ps=1.38u w=1u l=0.7u
X685 a_n3341_6527# a_n10106_3341# VSS.t8 rppd l=0.55u w=1.5u
X686 VDD.t875 a_n6543_n10895# a_n2002_n4396# VDD.t0 sg13_lv_pmos ad=0.19p pd=1.38u as=0.19p ps=1.38u w=1u l=0.7u
X687 Vop.t106 a_1220_1772# VDD.t357 VDD.t1 sg13_lv_pmos ad=0.2603p pd=1.75u as=0.4658p ps=3.42u w=1.37u l=0.35u
X688 a_n2002_n4396# VREF.t0 a_36_n4396# VDD.t0 sg13_lv_pmos ad=0.24415p pd=1.665u as=0.24415p ps=1.665u w=1.285u l=0.35u
X689 Vop.t111 a_1220_1772# VDD.t400 VDD.t1 sg13_lv_pmos ad=0.2603p pd=1.75u as=0.2603p ps=1.75u w=1.37u l=0.35u
X690 a_n3162_51# VPin.t0 a_n1828_1772# VSS.t150 sg13_lv_nmos ad=0.209p pd=1.48u as=0.209p ps=1.48u w=1.1u l=0.15u
X691 a_n2002_n4396# VREF.t0 a_36_n4396# VDD.t0 sg13_lv_pmos ad=0.24415p pd=1.665u as=0.24415p ps=1.665u w=1.285u l=0.35u
X692 a_n14155_n5285# a_n14155_n5285# VDD.t648 VDD.t642 sg13_lv_pmos ad=1.9p pd=10.38u as=1.9p ps=10.38u w=10u l=1u
X693 Vop.t62 a_1220_1772# VDD.t488 VDD.t1 sg13_lv_pmos ad=0.2603p pd=1.75u as=0.2603p ps=1.75u w=1.37u l=0.35u
X694 VDD.t972 a_n6543_n10895# a_n2002_n4396# VDD.t0 sg13_lv_pmos ad=0.19p pd=1.38u as=0.19p ps=1.38u w=1u l=0.7u
X695 VDD.t584 a_1220_1772# Vop.t130 VDD.t1 sg13_lv_pmos ad=0.2603p pd=1.75u as=0.2603p ps=1.75u w=1.37u l=0.35u
X696 Vop.t6 a_n10179_n275# VSS.t118 VSS.t9 sg13_lv_nmos ad=0.912p pd=5.18u as=0.912p ps=5.18u w=4.8u l=1.06u
X697 VSS.t54 a_n10179_n275# Von.t17 VSS.t17 sg13_lv_nmos ad=0.912p pd=5.18u as=0.912p ps=5.18u w=4.8u l=1.06u
X698 a_n14528_n9920# VOUTN.t26 a_n20570_n9414# VSS.t262 sg13_lv_nmos ad=1.9p pd=10.38u as=1.9p ps=10.38u w=10u l=0.5u
X699 VDD.t528 a_1220_1772# Vop.t84 VDD.t1 sg13_lv_pmos ad=0.2603p pd=1.75u as=0.2603p ps=1.75u w=1.37u l=0.35u
X700 a_n2373_n10895# a_n6543_n9623# a_n3721_n10895# VSS.t313 sg13_lv_nmos ad=1.14p pd=6.38u as=1.14p ps=6.38u w=6u l=6.4u
X701 a_n14528_n9920# VOUTN.t26 a_n20570_n9414# VSS.t260 sg13_lv_nmos ad=1.9p pd=10.38u as=1.9p ps=10.38u w=10u l=0.5u
X702 VDD.t699 a_n6543_n10895# a_n6543_n10895# VDD.t0 sg13_lv_pmos ad=0.19p pd=1.38u as=0.19p ps=1.38u w=1u l=0.7u
X703 a_n3381_1772# a_n10013_2465# VDD.t15 VDD.t1 sg13_lv_pmos ad=1.33p pd=7.38u as=1.33p ps=7.38u w=7u l=0.7u
X704 a_13228_n9920# VOUTP.t26 a_11652_n9920# VSS.t6 sg13_lv_nmos ad=1.9p pd=10.38u as=1.9p ps=10.38u w=10u l=0.5u
X705 a_n2002_n4396# a_n6543_n10895# VDD.t867 VDD.t0 sg13_lv_pmos ad=0.19p pd=1.38u as=0.19p ps=1.38u w=1u l=0.7u
X706 a_n3381_1772# a_n10013_2465# VDD.t2 VDD.t1 sg13_lv_pmos ad=1.33p pd=7.38u as=2.38p ps=14.68u w=7u l=0.7u
X707 a_n10106_3341# a_n8929_2739# a_n1828_1772# VSS.t322 sg13_lv_nmos ad=0.361p pd=2.28u as=0.646p ps=4.48u w=1.9u l=0.16u
X708 a_n5006_n3441# a_n6543_n10895# VDD.t813 VDD.t0 sg13_lv_pmos ad=0.19p pd=1.38u as=0.19p ps=1.38u w=1u l=0.7u
X709 VDD.t112 a_n10106_3341# Von.t119 VDD.t1 sg13_lv_pmos ad=0.2603p pd=1.75u as=0.2603p ps=1.75u w=1.37u l=0.35u
X710 a_11652_n9920# VOUTP.t26 a_13228_n9920# VSS.t1 sg13_lv_nmos ad=1.9p pd=10.38u as=1.9p ps=10.38u w=10u l=0.5u
X711 CMFBout.t20 Von.t158 a_n5006_n3441# VDD.t0 sg13_lv_pmos ad=0.24415p pd=1.665u as=0.24415p ps=1.665u w=1.285u l=0.35u
X712 VDD.t166 a_n10106_3341# Von.t67 VDD.t1 sg13_lv_pmos ad=0.2603p pd=1.75u as=0.2603p ps=1.75u w=1.37u l=0.35u
X713 a_n5006_n3441# VREF.t0 a_36_n4396# VDD.t0 sg13_lv_pmos ad=0.24415p pd=1.665u as=0.24415p ps=1.665u w=1.285u l=0.35u
X714 VDD.t138 a_n10106_3341# Von.t115 VDD.t1 sg13_lv_pmos ad=0.2603p pd=1.75u as=0.2603p ps=1.75u w=1.37u l=0.35u
X715 a_n14528_n9920# Von.t157 a_n14155_n5285# VSS.t306 sg13_lv_nmos ad=3.4p pd=20.68u as=1.9p ps=10.38u w=10u l=0.5u
X716 VDD.t855 a_n6543_n10895# a_n5006_n3441# VDD.t0 sg13_lv_pmos ad=0.19p pd=1.38u as=0.19p ps=1.38u w=1u l=0.7u
X717 Vop.t73 a_1220_1772# VDD.t470 VDD.t1 sg13_lv_pmos ad=0.2603p pd=1.75u as=0.2603p ps=1.75u w=1.37u l=0.35u
X718 a_n3721_n10895# a_n6543_n9623# a_n2373_n10895# VSS.t314 sg13_lv_nmos ad=1.14p pd=6.38u as=1.14p ps=6.38u w=6u l=6.4u
X719 VSS.t96 a_n10179_n275# Von.t16 VSS.t11 sg13_lv_nmos ad=0.912p pd=5.18u as=1.632p ps=10.28u w=4.8u l=1.06u
X720 Vop.t144 a_1220_1772# VDD.t438 VDD.t1 sg13_lv_pmos ad=0.2603p pd=1.75u as=0.2603p ps=1.75u w=1.37u l=0.35u
X721 VDD.t759 a_n6543_n10895# a_n5006_n3441# VDD.t0 sg13_lv_pmos ad=0.19p pd=1.38u as=0.19p ps=1.38u w=1u l=0.7u
X722 VSS.t129 a_n10179_n275# a_n10179_n275# VSS.t128 sg13_lv_nmos ad=1.632p pd=10.28u as=1.632p ps=10.28u w=4.8u l=1.06u
X723 a_n10106_3341# a_n8929_2739# a_n1828_1772# VSS.t322 sg13_lv_nmos ad=0.361p pd=2.28u as=0.646p ps=4.48u w=1.9u l=0.16u
X724 a_286_1773# a_n8929_2739# a_1220_1772# VSS.t331 sg13_lv_nmos ad=0.361p pd=2.28u as=0.361p ps=2.28u w=1.9u l=0.16u
X725 VDD.t641 a_11820_n9920# a_13228_n9920# VDD.t633 sg13_lv_pmos ad=3.4p pd=20.68u as=1.9p ps=10.38u w=10u l=1u
X726 Vop.t68 a_1220_1772# VDD.t547 VDD.t1 sg13_lv_pmos ad=0.2603p pd=1.75u as=0.4658p ps=3.42u w=1.37u l=0.35u
X727 VDD.t900 a_n6543_n10895# a_n5006_n3441# VDD.t0 sg13_lv_pmos ad=0.19p pd=1.38u as=0.19p ps=1.38u w=1u l=0.7u
X728 a_n3162_51# VNin.t0 a_286_1773# VSS.t145 sg13_lv_nmos ad=0.209p pd=1.48u as=0.209p ps=1.48u w=1.1u l=0.15u
X729 a_286_1773# VNin.t0 a_n3162_51# VSS.t146 sg13_lv_nmos ad=0.209p pd=1.48u as=0.209p ps=1.48u w=1.1u l=0.15u
X730 VDD.t842 a_n6543_n10895# a_n2002_n4396# VDD.t0 sg13_lv_pmos ad=0.19p pd=1.38u as=0.19p ps=1.38u w=1u l=0.7u
X731 VDD.t659 a_n6543_n10895# a_n6543_n10895# VDD.t0 sg13_lv_pmos ad=0.19p pd=1.38u as=0.19p ps=1.38u w=1u l=0.7u
X732 VDD.t829 a_n6543_n10895# a_n2002_n4396# VDD.t0 sg13_lv_pmos ad=0.19p pd=1.38u as=0.19p ps=1.38u w=1u l=0.7u
X733 VDD.t7 a_n10013_2465# a_n3381_1772# VDD.t1 sg13_lv_pmos ad=2.38p pd=14.68u as=1.33p ps=7.38u w=7u l=0.7u
X734 Von.t139 a_n10106_3341# VDD.t342 VDD.t1 sg13_lv_pmos ad=0.2603p pd=1.75u as=0.2603p ps=1.75u w=1.37u l=0.35u
X735 a_n5006_n3441# a_n6543_n10895# VDD.t942 VDD.t0 sg13_lv_pmos ad=0.19p pd=1.38u as=0.19p ps=1.38u w=1u l=0.7u
X736 VDD.t422 a_1220_1772# Vop.t126 VDD.t1 sg13_lv_pmos ad=0.2603p pd=1.75u as=0.2603p ps=1.75u w=1.37u l=0.35u
X737 VDD.t374 a_1220_1772# Vop.t114 VDD.t1 sg13_lv_pmos ad=0.2603p pd=1.75u as=0.2603p ps=1.75u w=1.37u l=0.35u
X738 a_n5006_n3441# a_n6543_n10895# VDD.t956 VDD.t0 sg13_lv_pmos ad=0.19p pd=1.38u as=0.19p ps=1.38u w=1u l=0.7u
X739 VDD.t390 a_1220_1772# Vop.t113 VDD.t1 sg13_lv_pmos ad=0.2603p pd=1.75u as=0.2603p ps=1.75u w=1.37u l=0.35u
X740 VDD.t556 a_1220_1772# Vop.t42 VDD.t1 sg13_lv_pmos ad=0.4658p pd=3.42u as=0.2603p ps=1.75u w=1.37u l=0.35u
X741 VDD.t294 a_n10106_3341# Von.t126 VDD.t1 sg13_lv_pmos ad=0.4658p pd=3.42u as=0.2603p ps=1.75u w=1.37u l=0.35u
X742 VDD.t925 a_n6543_n10895# a_n2002_n4396# VDD.t0 sg13_lv_pmos ad=0.19p pd=1.38u as=0.19p ps=1.38u w=1u l=0.7u
X743 VOUTN.t20 a_n20570_n9414# VDD.t78 VSS.t133 sg13_lv_nmos ad=3.4p pd=20.68u as=3.4p ps=20.68u w=10u l=0.15u
X744 a_286_1773# VNin.t0 a_n3162_51# VSS.t144 sg13_lv_nmos ad=0.209p pd=1.48u as=0.209p ps=1.48u w=1.1u l=0.15u
X745 Von.t77 a_n10106_3341# VDD.t230 VDD.t1 sg13_lv_pmos ad=0.2603p pd=1.75u as=0.2603p ps=1.75u w=1.37u l=0.35u
X746 VSS.t180 CMFBin.t25 a_n3162_51# VSS.t179 sg13_lv_nmos ad=0.6327p pd=3.71u as=0.6327p ps=3.71u w=3.33u l=0.2u
X747 VDD.t182 a_n10106_3341# Von.t143 VDD.t1 sg13_lv_pmos ad=0.2603p pd=1.75u as=0.2603p ps=1.75u w=1.37u l=0.35u
X748 VDD.t614 a_13228_n9920# VOUTP.t19 VSS.t168 sg13_lv_nmos ad=3.4p pd=20.68u as=3.4p ps=20.68u w=10u l=0.15u
X749 Von.t20 a_n10179_n275# VSS.t102 VSS.t22 sg13_lv_nmos ad=0.912p pd=5.18u as=0.912p ps=5.18u w=4.8u l=1.06u
X750 a_n1828_1772# VPin.t0 a_n3162_51# VSS.t151 sg13_lv_nmos ad=0.209p pd=1.48u as=0.209p ps=1.48u w=1.1u l=0.15u
X751 VDD.t713 a_n6543_n10895# a_n5006_n3441# VDD.t0 sg13_lv_pmos ad=0.19p pd=1.38u as=0.19p ps=1.38u w=1u l=0.7u
X752 a_n14528_n9920# Von.t157 a_n14155_n5285# VSS.t302 sg13_lv_nmos ad=1.9p pd=10.38u as=1.9p ps=10.38u w=10u l=0.5u
X753 Vop.t26 a_n10179_n275# VSS.t66 VSS.t9 sg13_lv_nmos ad=0.912p pd=5.18u as=0.912p ps=5.18u w=4.8u l=1.06u
X754 VDD.t23 a_n10013_2465# a_n3381_1772# VDD.t1 sg13_lv_pmos ad=1.33p pd=7.38u as=1.33p ps=7.38u w=7u l=0.7u
X755 Vop.t61 a_1220_1772# VDD.t497 VDD.t1 sg13_lv_pmos ad=0.2603p pd=1.75u as=0.4658p ps=3.42u w=1.37u l=0.35u
X756 VDD.t264 a_n10106_3341# Von.t43 VDD.t1 sg13_lv_pmos ad=0.4658p pd=3.42u as=0.2603p ps=1.75u w=1.37u l=0.35u
X757 VSS.t270 a_n13845_n10915# VOUTN.t25 VSS.t269 sg13_lv_nmos ad=1.02p pd=6.68u as=1.02p ps=6.68u w=3u l=1u
X758 a_881_4136# a_n9221_n275# a_1220_1772# VDD.t1 sg13_lv_pmos ad=1.377p pd=8.78u as=0.7695p ps=4.43u w=4.05u l=0.5u
X759 a_n6543_n10895# a_n6543_n10895# VDD.t703 VDD.t0 sg13_lv_pmos ad=0.19p pd=1.38u as=0.19p ps=1.38u w=1u l=0.7u
X760 a_n3162_51# VNin.t0 a_286_1773# VSS.t143 sg13_lv_nmos ad=0.209p pd=1.48u as=0.209p ps=1.48u w=1.1u l=0.15u
X761 VDD.t978 a_n6543_n10895# a_n2002_n4396# VDD.t0 sg13_lv_pmos ad=0.19p pd=1.38u as=0.19p ps=1.38u w=1u l=0.7u
X762 a_n6543_n10895# a_n6543_n10895# VDD.t689 VDD.t0 sg13_lv_pmos ad=0.19p pd=1.38u as=0.19p ps=1.38u w=1u l=0.7u
X763 VDD.t47 a_n10013_2465# a_881_4136# VDD.t1 sg13_lv_pmos ad=1.33p pd=7.38u as=1.33p ps=7.38u w=7u l=0.7u
X764 VOUTP.t23 a_13228_n9920# VDD.t603 VSS.t173 sg13_lv_nmos ad=3.4p pd=20.68u as=3.4p ps=20.68u w=10u l=0.15u
X765 VDD.t354 a_1220_1772# Vop.t45 VDD.t1 sg13_lv_pmos ad=0.2603p pd=1.75u as=0.2603p ps=1.75u w=1.37u l=0.35u
X766 a_n10106_3341# a_n9221_n275# a_n3381_1772# VDD.t1 sg13_lv_pmos ad=0.7695p pd=4.43u as=1.377p ps=8.78u w=4.05u l=0.5u
X767 a_n2002_n4396# a_n6543_n10895# VDD.t966 VDD.t0 sg13_lv_pmos ad=0.19p pd=1.38u as=0.19p ps=1.38u w=1u l=0.7u
X768 VDD.t739 a_n6543_n10895# a_n2002_n4396# VDD.t0 sg13_lv_pmos ad=0.19p pd=1.38u as=0.19p ps=1.38u w=1u l=0.7u
X769 VDD.t506 a_1220_1772# Vop.t79 VDD.t1 sg13_lv_pmos ad=0.4658p pd=3.42u as=0.2603p ps=1.75u w=1.37u l=0.35u
X770 a_n5006_n3441# a_n6543_n10895# VDD.t863 VDD.t0 sg13_lv_pmos ad=0.19p pd=1.38u as=0.19p ps=1.38u w=1u l=0.7u
X771 VDD.t705 a_n6543_n10895# a_n6543_n10895# VDD.t0 sg13_lv_pmos ad=0.34p pd=2.68u as=0.19p ps=1.38u w=1u l=0.7u
X772 VDD.t548 a_1220_1772# Vop.t68 VDD.t1 sg13_lv_pmos ad=0.2603p pd=1.75u as=0.2603p ps=1.75u w=1.37u l=0.35u
X773 Von.t115 a_n10106_3341# VDD.t136 VDD.t1 sg13_lv_pmos ad=0.2603p pd=1.75u as=0.2603p ps=1.75u w=1.37u l=0.35u
X774 VDD.t160 a_n10106_3341# Von.t145 VDD.t1 sg13_lv_pmos ad=0.2603p pd=1.75u as=0.2603p ps=1.75u w=1.37u l=0.35u
X775 a_n5006_n3441# Von.t158 CMFBout.t27 VDD.t0 sg13_lv_pmos ad=0.24415p pd=1.665u as=0.24415p ps=1.665u w=1.285u l=0.35u
X776 a_1220_1772# a_n8929_2739# a_286_1773# VSS.t330 sg13_lv_nmos ad=0.361p pd=2.28u as=0.361p ps=2.28u w=1.9u l=0.16u
X777 Vop.t20 a_n10179_n275# VSS.t111 VSS.t9 sg13_lv_nmos ad=0.912p pd=5.18u as=0.912p ps=5.18u w=4.8u l=1.06u
X778 Vop.t97 a_1220_1772# VDD.t422 VDD.t1 sg13_lv_pmos ad=0.2603p pd=1.75u as=0.2603p ps=1.75u w=1.37u l=0.35u
X779 a_n5006_n3441# a_n6543_n10895# VDD.t767 VDD.t0 sg13_lv_pmos ad=0.19p pd=1.38u as=0.19p ps=1.38u w=1u l=0.7u
X780 a_286_1773# a_n8929_2739# a_1220_1772# VSS.t333 sg13_lv_nmos ad=0.646p pd=4.48u as=0.361p ps=2.28u w=1.9u l=0.16u
X781 Von.t44 a_n10106_3341# VDD.t275 VDD.t1 sg13_lv_pmos ad=0.2603p pd=1.75u as=0.4658p ps=3.42u w=1.37u l=0.35u
X782 a_n5006_n3441# a_n6543_n10895# VDD.t894 VDD.t0 sg13_lv_pmos ad=0.19p pd=1.38u as=0.19p ps=1.38u w=1u l=0.7u
X783 a_n5006_n3441# a_n6543_n10895# VDD.t908 VDD.t0 sg13_lv_pmos ad=0.19p pd=1.38u as=0.19p ps=1.38u w=1u l=0.7u
X784 Vop.t39 a_1220_1772# VDD.t567 VDD.t1 sg13_lv_pmos ad=0.2603p pd=1.75u as=0.4658p ps=3.42u w=1.37u l=0.35u
X785 a_36_n4396# VREF.t0 a_n5006_n3441# VDD.t0 sg13_lv_pmos ad=0.24415p pd=1.665u as=0.24415p ps=1.665u w=1.285u l=0.35u
X786 a_n2002_n4396# a_n6543_n10895# VDD.t833 VDD.t0 sg13_lv_pmos ad=0.19p pd=1.38u as=0.19p ps=1.38u w=1u l=0.7u
X787 a_n5006_n3441# Von.t158 CMFBout.t23 VDD.t0 sg13_lv_pmos ad=0.24415p pd=1.665u as=0.4369p ps=3.25u w=1.285u l=0.35u
X788 Vop.t63 a_1220_1772# VDD.t490 VDD.t1 sg13_lv_pmos ad=0.2603p pd=1.75u as=0.2603p ps=1.75u w=1.37u l=0.35u
X789 a_n3162_51# VNin.t0 a_286_1773# VSS.t143 sg13_lv_nmos ad=0.209p pd=1.48u as=0.209p ps=1.48u w=1.1u l=0.15u
X790 Vop.t75 a_1220_1772# VDD.t458 VDD.t1 sg13_lv_pmos ad=0.2603p pd=1.75u as=0.2603p ps=1.75u w=1.37u l=0.35u
X791 a_n5006_n3441# VREF.t0 a_36_n4396# VDD.t0 sg13_lv_pmos ad=0.24415p pd=1.665u as=0.24415p ps=1.665u w=1.285u l=0.35u
X792 a_286_1773# VNin.t0 a_n3162_51# VSS.t144 sg13_lv_nmos ad=0.209p pd=1.48u as=0.209p ps=1.48u w=1.1u l=0.15u
X793 VSS.t249 CMFBin.t2 a_n3162_51# VSS.t248 sg13_lv_nmos ad=0.6327p pd=3.71u as=0.6327p ps=3.71u w=3.33u l=0.2u
X794 Vop.t132 a_1220_1772# VDD.t534 VDD.t1 sg13_lv_pmos ad=0.2603p pd=1.75u as=0.2603p ps=1.75u w=1.37u l=0.35u
X795 a_881_4136# a_n9221_n275# a_1220_1772# VDD.t1 sg13_lv_pmos ad=1.377p pd=8.78u as=0.7695p ps=4.43u w=4.05u l=0.5u
X796 VDD.t498 a_1220_1772# Vop.t61 VDD.t1 sg13_lv_pmos ad=0.2603p pd=1.75u as=0.2603p ps=1.75u w=1.37u l=0.35u
X797 VDD.t576 a_1220_1772# Vop.t32 VDD.t1 sg13_lv_pmos ad=0.4658p pd=3.42u as=0.2603p ps=1.75u w=1.37u l=0.35u
X798 a_n2002_n4396# a_n6543_n10895# VDD.t974 VDD.t0 sg13_lv_pmos ad=0.19p pd=1.38u as=0.19p ps=1.38u w=1u l=0.7u
X799 a_11652_n9920# VOUTP.t26 a_13228_n9920# VSS.t5 sg13_lv_nmos ad=1.9p pd=10.38u as=1.9p ps=10.38u w=10u l=0.5u
X800 a_n5006_n3441# a_n6543_n10895# VDD.t802 VDD.t0 sg13_lv_pmos ad=0.19p pd=1.38u as=0.19p ps=1.38u w=1u l=0.7u
X801 a_1220_1772# a_n9221_n275# a_881_4136# VDD.t1 sg13_lv_pmos ad=0.7695p pd=4.43u as=0.7695p ps=4.43u w=4.05u l=0.5u
X802 Vop.t28 a_n10179_n275# VSS.t130 VSS.t9 sg13_lv_nmos ad=1.632p pd=10.28u as=0.912p ps=5.18u w=4.8u l=1.06u
X803 a_n10106_3341# a_n9221_n275# a_n3381_1772# VDD.t1 sg13_lv_pmos ad=0.7695p pd=4.43u as=1.377p ps=8.78u w=4.05u l=0.5u
X804 a_n3381_1772# a_n10013_2465# VDD.t8 VDD.t1 sg13_lv_pmos ad=1.33p pd=7.38u as=2.38p ps=14.68u w=7u l=0.7u
X805 VDD.t663 a_n6543_n10895# a_n6543_n10895# VDD.t0 sg13_lv_pmos ad=0.19p pd=1.38u as=0.19p ps=1.38u w=1u l=0.7u
X806 VDD.t931 a_n6543_n10895# a_n2002_n4396# VDD.t0 sg13_lv_pmos ad=0.19p pd=1.38u as=0.19p ps=1.38u w=1u l=0.7u
X807 VSS.t198 CMFBin.t19 a_n3162_51# VSS.t197 sg13_lv_nmos ad=0.6327p pd=3.71u as=0.6327p ps=3.71u w=3.33u l=0.2u
X808 a_n3381_1772# a_n9221_n275# a_n10106_3341# VDD.t1 sg13_lv_pmos ad=0.7695p pd=4.43u as=0.7695p ps=4.43u w=4.05u l=0.5u
X809 VSS.t27 a_n10179_n275# Von.t7 VSS.t26 sg13_lv_nmos ad=1.632p pd=10.28u as=0.912p ps=5.18u w=4.8u l=1.06u
X810 a_n5006_n3441# a_n6543_n10895# VDD.t707 VDD.t0 sg13_lv_pmos ad=0.19p pd=1.38u as=0.19p ps=1.38u w=1u l=0.7u
X811 VDD.t3 a_n10013_2465# a_n3381_1772# VDD.t1 sg13_lv_pmos ad=1.33p pd=7.38u as=1.33p ps=7.38u w=7u l=0.7u
X812 a_n2002_n4396# VREF.t0 a_36_n4396# VDD.t0 sg13_lv_pmos ad=0.24415p pd=1.665u as=0.24415p ps=1.665u w=1.285u l=0.35u
X813 a_n5006_n3441# a_n6543_n10895# VDD.t721 VDD.t0 sg13_lv_pmos ad=0.19p pd=1.38u as=0.19p ps=1.38u w=1u l=0.7u
X814 a_n8929_2739# a_n9221_n275# VDD.t345 VDD.t1 sg13_lv_pmos ad=0.697p pd=4.78u as=0.3895p ps=2.43u w=2.05u l=0.35u
X815 a_n2002_n4396# a_n6543_n10895# VDD.t918 VDD.t0 sg13_lv_pmos ad=0.19p pd=1.38u as=0.19p ps=1.38u w=1u l=0.7u
X816 VDD.t136 a_n10106_3341# Von.t68 VDD.t1 sg13_lv_pmos ad=0.2603p pd=1.75u as=0.2603p ps=1.75u w=1.37u l=0.35u
X817 a_n1828_1772# VPin.t0 a_n3162_51# VSS.t153 sg13_lv_nmos ad=0.209p pd=1.48u as=0.209p ps=1.48u w=1.1u l=0.15u
X818 a_11652_n9920# IB.t1 VSS.t281 VSS.t280 sg13_lv_nmos ad=0.57p pd=3.38u as=1.02p ps=6.68u w=3u l=1u
X819 VSS.t319 a_n6543_n9623# a_n6543_n10895# VSS.t308 sg13_lv_nmos ad=1.14p pd=6.38u as=2.04p ps=12.68u w=6u l=6.4u
X820 a_1220_1772# a_n9221_n275# a_881_4136# VDD.t1 sg13_lv_pmos ad=0.7695p pd=4.43u as=1.377p ps=8.78u w=4.05u l=0.5u
X821 Vop.t145 a_1220_1772# VDD.t440 VDD.t1 sg13_lv_pmos ad=0.2603p pd=1.75u as=0.2603p ps=1.75u w=1.37u l=0.35u
X822 VDD.t57 a_n10013_2465# a_881_4136# VDD.t1 sg13_lv_pmos ad=2.38p pd=14.68u as=1.33p ps=7.38u w=7u l=0.7u
X823 a_n5006_n3441# a_n6543_n10895# VDD.t851 VDD.t0 sg13_lv_pmos ad=0.19p pd=1.38u as=0.19p ps=1.38u w=1u l=0.7u
X824 a_n3381_1772# a_n9221_n275# a_n10106_3341# VDD.t1 sg13_lv_pmos ad=1.377p pd=8.78u as=0.7695p ps=4.43u w=4.05u l=0.5u
X825 a_n3721_n10895# a_n6543_n9623# a_n2373_n10895# VSS.t316 sg13_lv_nmos ad=1.14p pd=6.38u as=1.14p ps=6.38u w=6u l=6.4u
X826 Von.t145 a_n10106_3341# VDD.t158 VDD.t1 sg13_lv_pmos ad=0.2603p pd=1.75u as=0.2603p ps=1.75u w=1.37u l=0.35u
X827 VDD.t568 a_1220_1772# Vop.t39 VDD.t1 sg13_lv_pmos ad=0.2603p pd=1.75u as=0.2603p ps=1.75u w=1.37u l=0.35u
X828 a_n5006_n3441# a_n6543_n10895# VDD.t944 VDD.t0 sg13_lv_pmos ad=0.19p pd=1.38u as=0.19p ps=1.38u w=1u l=0.7u
X829 VDD.t831 a_n6543_n10895# a_n2002_n4396# VDD.t0 sg13_lv_pmos ad=0.19p pd=1.38u as=0.19p ps=1.38u w=1u l=0.7u
X830 VDD.t745 a_n6543_n10895# a_n2002_n4396# VDD.t0 sg13_lv_pmos ad=0.19p pd=1.38u as=0.19p ps=1.38u w=1u l=0.7u
X831 VSS.t120 a_n10179_n275# Vop.t6 VSS.t9 sg13_lv_nmos ad=0.912p pd=5.18u as=0.912p ps=5.18u w=4.8u l=1.06u
X832 Von.t17 a_n10179_n275# VSS.t52 VSS.t16 sg13_lv_nmos ad=0.912p pd=5.18u as=0.912p ps=5.18u w=4.8u l=1.06u
X833 VDD.t13 a_n10013_2465# a_n3381_1772# VDD.t1 sg13_lv_pmos ad=2.38p pd=14.68u as=1.33p ps=7.38u w=7u l=0.7u
X834 a_n2002_n4396# a_n6543_n10895# VDD.t733 VDD.t0 sg13_lv_pmos ad=0.19p pd=1.38u as=0.19p ps=1.38u w=1u l=0.7u
X835 VDD.t424 a_1220_1772# Vop.t97 VDD.t1 sg13_lv_pmos ad=0.2603p pd=1.75u as=0.2603p ps=1.75u w=1.37u l=0.35u
X836 Von.t135 a_n10106_3341# VDD.t312 VDD.t1 sg13_lv_pmos ad=0.2603p pd=1.75u as=0.2603p ps=1.75u w=1.37u l=0.35u
X837 VDD.t134 a_n10106_3341# Von.t54 VDD.t1 sg13_lv_pmos ad=0.4658p pd=3.42u as=0.2603p ps=1.75u w=1.37u l=0.35u
X838 VDD.t392 a_1220_1772# Vop.t155 VDD.t1 sg13_lv_pmos ad=0.2603p pd=1.75u as=0.2603p ps=1.75u w=1.37u l=0.35u
X839 VDD.t612 a_13228_n9920# VOUTP.t5 VSS.t174 sg13_lv_nmos ad=3.4p pd=20.68u as=3.4p ps=20.68u w=10u l=0.15u
X840 a_n2373_n10895# a_n6543_n9623# a_n3721_n10895# VSS.t311 sg13_lv_nmos ad=1.14p pd=6.38u as=2.04p ps=12.68u w=6u l=6.4u
X841 VDD.t128 a_n10106_3341# Von.t95 VDD.t1 sg13_lv_pmos ad=0.2603p pd=1.75u as=0.2603p ps=1.75u w=1.37u l=0.35u
X842 Von.t89 a_n10106_3341# VDD.t200 VDD.t1 sg13_lv_pmos ad=0.2603p pd=1.75u as=0.2603p ps=1.75u w=1.37u l=0.35u
X843 VSS.t30 a_n10179_n275# Von.t24 VSS.t14 sg13_lv_nmos ad=0.912p pd=5.18u as=0.912p ps=5.18u w=4.8u l=1.06u
X844 a_n14528_n9920# VOUTN.t26 a_n20570_n9414# VSS.t264 sg13_lv_nmos ad=1.9p pd=10.38u as=1.9p ps=10.38u w=10u l=0.5u
X845 VDD.t180 a_n10106_3341# Von.t148 VDD.t1 sg13_lv_pmos ad=0.2603p pd=1.75u as=0.2603p ps=1.75u w=1.37u l=0.35u
X846 VDD.t152 a_n10106_3341# Von.t109 VDD.t1 sg13_lv_pmos ad=0.2603p pd=1.75u as=0.2603p ps=1.75u w=1.37u l=0.35u
X847 CMFBout.t21 Von.t158 a_n5006_n3441# VDD.t0 sg13_lv_pmos ad=0.24415p pd=1.665u as=0.24415p ps=1.665u w=1.285u l=0.35u
X848 a_n2002_n4396# a_n6543_n10895# VDD.t927 VDD.t0 sg13_lv_pmos ad=0.19p pd=1.38u as=0.19p ps=1.38u w=1u l=0.7u
X849 VOUTN.t19 a_n20570_n9414# VDD.t84 VSS.t139 sg13_lv_nmos ad=3.4p pd=20.68u as=3.4p ps=20.68u w=10u l=0.15u
X850 a_n5006_n3441# a_n6543_n10895# VDD.t960 VDD.t0 sg13_lv_pmos ad=0.19p pd=1.38u as=0.19p ps=1.38u w=1u l=0.7u
X851 a_n2002_n4396# a_n6543_n10895# VDD.t823 VDD.t0 sg13_lv_pmos ad=0.19p pd=1.38u as=0.19p ps=1.38u w=1u l=0.7u
X852 a_n2373_n10895# a_n6543_n9623# a_n3721_n10895# VSS.t313 sg13_lv_nmos ad=1.14p pd=6.38u as=1.14p ps=6.38u w=6u l=6.4u
X853 Von.t124 a_n10106_3341# VDD.t295 VDD.t1 sg13_lv_pmos ad=0.2603p pd=1.75u as=0.4658p ps=3.42u w=1.37u l=0.35u
X854 Von.t2 a_n10179_n275# VSS.t36 VSS.t25 sg13_lv_nmos ad=0.912p pd=5.18u as=0.912p ps=5.18u w=4.8u l=1.06u
X855 Vop.t52 a_1220_1772# VDD.t587 VDD.t1 sg13_lv_pmos ad=0.2603p pd=1.75u as=0.4658p ps=3.42u w=1.37u l=0.35u
X856 VDD.t811 a_n6543_n10895# a_n5006_n3441# VDD.t0 sg13_lv_pmos ad=0.19p pd=1.38u as=0.19p ps=1.38u w=1u l=0.7u
X857 VDD.t644 a_n14155_n5285# a_n20570_n9414# VDD.t642 sg13_lv_pmos ad=1.9p pd=10.38u as=1.9p ps=10.38u w=10u l=1u
X858 a_n3162_51# VPin.t0 a_n1828_1772# VSS.t154 sg13_lv_nmos ad=0.374p pd=2.88u as=0.209p ps=1.48u w=1.1u l=0.15u
X859 Vop.t65 a_1220_1772# VDD.t478 VDD.t1 sg13_lv_pmos ad=0.2603p pd=1.75u as=0.2603p ps=1.75u w=1.37u l=0.35u
X860 a_n1828_1772# VPin.t0 a_n3162_51# VSS.t153 sg13_lv_nmos ad=0.209p pd=1.48u as=0.209p ps=1.48u w=1.1u l=0.15u
X861 a_36_n4396# VREF.t0 a_n5006_n3441# VDD.t0 sg13_lv_pmos ad=0.24415p pd=1.665u as=0.24415p ps=1.665u w=1.285u l=0.35u
X862 VDD.t693 a_n6543_n10895# a_n6543_n10895# VDD.t0 sg13_lv_pmos ad=0.19p pd=1.38u as=0.19p ps=1.38u w=1u l=0.7u
X863 Vop.t42 a_1220_1772# VDD.t554 VDD.t1 sg13_lv_pmos ad=0.2603p pd=1.75u as=0.2603p ps=1.75u w=1.37u l=0.35u
X864 a_36_n4396# a_36_n4396# VSS.t345 VSS.t346 sg13_lv_nmos ad=0.6327p pd=3.71u as=0.6327p ps=3.71u w=3.33u l=0.2u
X865 VDD.t158 a_n10106_3341# Von.t144 VDD.t1 sg13_lv_pmos ad=0.2603p pd=1.75u as=0.2603p ps=1.75u w=1.37u l=0.35u
X866 VDD.t596 a_1220_1772# Vop.t128 VDD.t1 sg13_lv_pmos ad=0.4658p pd=3.42u as=0.2603p ps=1.75u w=1.37u l=0.35u
X867 a_n2002_n4396# a_n6543_n10895# VDD.t741 VDD.t0 sg13_lv_pmos ad=0.19p pd=1.38u as=0.19p ps=1.38u w=1u l=0.7u
X868 Von.t34 a_n10106_3341# VDD.t270 VDD.t1 sg13_lv_pmos ad=0.2603p pd=1.75u as=0.2603p ps=1.75u w=1.37u l=0.35u
X869 VSS.t246 CMFBin.t3 a_n3162_51# VSS.t245 sg13_lv_nmos ad=0.6327p pd=3.71u as=0.6327p ps=3.71u w=3.33u l=0.2u
X870 VDD.t222 a_n10106_3341# Von.t102 VDD.t1 sg13_lv_pmos ad=0.2603p pd=1.75u as=0.2603p ps=1.75u w=1.37u l=0.35u
X871 a_n5006_n3441# a_n6543_n10895# VDD.t896 VDD.t0 sg13_lv_pmos ad=0.19p pd=1.38u as=0.19p ps=1.38u w=1u l=0.7u
X872 a_n2002_n4396# Vop.t158 CMFBout.t1 VDD.t0 sg13_lv_pmos ad=0.24415p pd=1.665u as=0.24415p ps=1.665u w=1.285u l=0.35u
X873 VDD.t848 a_n6543_n10895# a_n5006_n3441# VDD.t0 sg13_lv_pmos ad=0.19p pd=1.38u as=0.19p ps=1.38u w=1u l=0.7u
X874 a_n2002_n4396# a_n6543_n10895# VDD.t778 VDD.t0 sg13_lv_pmos ad=0.19p pd=1.38u as=0.19p ps=1.38u w=1u l=0.7u
X875 Vop.t121 a_1220_1772# VDD.t392 VDD.t1 sg13_lv_pmos ad=0.2603p pd=1.75u as=0.2603p ps=1.75u w=1.37u l=0.35u
X876 Vop.t108 a_1220_1772# VDD.t384 VDD.t1 sg13_lv_pmos ad=0.2603p pd=1.75u as=0.2603p ps=1.75u w=1.37u l=0.35u
X877 Von.t73 a_n10106_3341# VDD.t245 VDD.t1 sg13_lv_pmos ad=0.2603p pd=1.75u as=0.4658p ps=3.42u w=1.37u l=0.35u
X878 VSS.t102 a_n10179_n275# Von.t9 VSS.t20 sg13_lv_nmos ad=0.912p pd=5.18u as=0.912p ps=5.18u w=4.8u l=1.06u
X879 VSS.t72 a_n10179_n275# Vop.t5 VSS.t9 sg13_lv_nmos ad=0.912p pd=5.18u as=0.912p ps=5.18u w=4.8u l=1.06u
X880 VDD.t765 a_n6543_n10895# a_n5006_n3441# VDD.t0 sg13_lv_pmos ad=0.19p pd=1.38u as=0.19p ps=1.38u w=1u l=0.7u
X881 VSS.t201 CMFBin.t18 a_n3162_51# VSS.t200 sg13_lv_nmos ad=0.6327p pd=3.71u as=0.6327p ps=3.71u w=3.33u l=0.2u
X882 a_n14155_n5285# Von.t157 a_n14528_n9920# VSS.t299 sg13_lv_nmos ad=1.9p pd=10.38u as=1.9p ps=10.38u w=10u l=0.5u
X883 Vop.t76 a_1220_1772# VDD.t460 VDD.t1 sg13_lv_pmos ad=0.2603p pd=1.75u as=0.2603p ps=1.75u w=1.37u l=0.35u
X884 a_n2002_n4396# Vop.t158 CMFBout.t0 VDD.t0 sg13_lv_pmos ad=0.24415p pd=1.665u as=0.24415p ps=1.665u w=1.285u l=0.35u
X885 a_n2002_n4396# VREF.t0 a_36_n4396# VDD.t0 sg13_lv_pmos ad=0.24415p pd=1.665u as=0.24415p ps=1.665u w=1.285u l=0.35u
X886 VDD.t410 a_1220_1772# Vop.t127 VDD.t1 sg13_lv_pmos ad=0.2603p pd=1.75u as=0.2603p ps=1.75u w=1.37u l=0.35u
X887 Vop.t79 a_1220_1772# VDD.t504 VDD.t1 sg13_lv_pmos ad=0.2603p pd=1.75u as=0.2603p ps=1.75u w=1.37u l=0.35u
X888 Von.t57 a_n10106_3341# VDD.t116 VDD.t1 sg13_lv_pmos ad=0.2603p pd=1.75u as=0.2603p ps=1.75u w=1.37u l=0.35u
X889 a_n5006_n3441# a_n6543_n10895# VDD.t912 VDD.t0 sg13_lv_pmos ad=0.19p pd=1.38u as=0.19p ps=1.38u w=1u l=0.7u
X890 VNout.t0 VN.t0 VSS.t166 rppd l=6.73u w=0.6u
X891 Von.t148 a_n10106_3341# VDD.t178 VDD.t1 sg13_lv_pmos ad=0.2603p pd=1.75u as=0.2603p ps=1.75u w=1.37u l=0.35u
X892 VDD.t588 a_1220_1772# Vop.t52 VDD.t1 sg13_lv_pmos ad=0.2603p pd=1.75u as=0.2603p ps=1.75u w=1.37u l=0.35u
X893 a_n5006_n3441# a_n6543_n10895# VDD.t709 VDD.t0 sg13_lv_pmos ad=0.19p pd=1.38u as=0.19p ps=1.38u w=1u l=0.7u
X894 VDD.t675 a_n6543_n10895# a_n6543_n10895# VDD.t0 sg13_lv_pmos ad=0.19p pd=1.38u as=0.19p ps=1.38u w=1u l=0.7u
X895 VDD.t106 a_n10106_3341# Von.t30 VDD.t1 sg13_lv_pmos ad=0.2603p pd=1.75u as=0.2603p ps=1.75u w=1.37u l=0.35u
X896 CMFBout.t17 Von.t158 a_n5006_n3441# VDD.t0 sg13_lv_pmos ad=0.24415p pd=1.665u as=0.24415p ps=1.665u w=1.285u l=0.35u
X897 CMFBout.t5 Vop.t158 a_n2002_n4396# VDD.t0 sg13_lv_pmos ad=0.24415p pd=1.665u as=0.24415p ps=1.665u w=1.285u l=0.35u
X898 VDD.t9 a_n10013_2465# a_n3381_1772# VDD.t1 sg13_lv_pmos ad=1.33p pd=7.38u as=1.33p ps=7.38u w=7u l=0.7u
X899 Von.t136 a_n10106_3341# VDD.t332 VDD.t1 sg13_lv_pmos ad=0.2603p pd=1.75u as=0.2603p ps=1.75u w=1.37u l=0.35u
X900 a_n10179_n275# a_n3721_n10895# VDD.t623 VDD.t622 sg13_lv_pmos ad=1.14p pd=6.38u as=1.14p ps=6.38u w=6u l=2.5u
X901 a_n2002_n4396# a_n6543_n10895# VDD.t796 VDD.t0 sg13_lv_pmos ad=0.19p pd=1.38u as=0.19p ps=1.38u w=1u l=0.7u
X902 a_n3381_1772# a_n10013_2465# VDD.t3 VDD.t1 sg13_lv_pmos ad=1.33p pd=7.38u as=1.33p ps=7.38u w=7u l=0.7u
X903 VDD.t284 a_n10106_3341# Von.t50 VDD.t1 sg13_lv_pmos ad=0.4658p pd=3.42u as=0.2603p ps=1.75u w=1.37u l=0.35u
X904 a_n5006_n3441# a_n6543_n10895# VDD.t819 VDD.t0 sg13_lv_pmos ad=0.19p pd=1.38u as=0.19p ps=1.38u w=1u l=0.7u
X905 Von.t128 a_n10106_3341# VDD.t315 VDD.t1 sg13_lv_pmos ad=0.2603p pd=1.75u as=0.4658p ps=3.42u w=1.37u l=0.35u
X906 VDD.t628 a_n3721_n10895# a_n10179_n275# VDD.t622 sg13_lv_pmos ad=1.14p pd=6.38u as=1.14p ps=6.38u w=6u l=2.5u
X907 VDD.t681 a_n6543_n10895# a_n6543_n10895# VDD.t0 sg13_lv_pmos ad=0.19p pd=1.38u as=0.19p ps=1.38u w=1u l=0.7u
X908 VSS.t113 a_n10179_n275# Vop.t20 VSS.t9 sg13_lv_nmos ad=0.912p pd=5.18u as=0.912p ps=5.18u w=4.8u l=1.06u
X909 a_n5006_n3441# VREF.t0 a_36_n4396# VDD.t0 sg13_lv_pmos ad=0.24415p pd=1.665u as=0.24415p ps=1.665u w=1.285u l=0.35u
X910 Vop.t49 a_1220_1772# VDD.t367 VDD.t1 sg13_lv_pmos ad=0.2603p pd=1.75u as=0.4658p ps=3.42u w=1.37u l=0.35u
X911 a_n6543_n9623# a_n6543_n9623# VSS.t309 VSS.t310 sg13_lv_nmos ad=2.04p pd=12.68u as=1.14p ps=6.38u w=6u l=6.4u
X912 a_n5006_n3441# a_n6543_n10895# VDD.t725 VDD.t0 sg13_lv_pmos ad=0.19p pd=1.38u as=0.19p ps=1.38u w=1u l=0.7u
X913 Von.t51 a_n10106_3341# VDD.t96 VDD.t1 sg13_lv_pmos ad=0.2603p pd=1.75u as=0.2603p ps=1.75u w=1.37u l=0.35u
X914 a_n6543_n10895# a_n6543_n10895# VDD.t697 VDD.t0 sg13_lv_pmos ad=0.19p pd=1.38u as=0.19p ps=1.38u w=1u l=0.7u
X915 a_881_4136# a_n10013_2465# VDD.t55 VDD.t1 sg13_lv_pmos ad=1.33p pd=7.38u as=1.33p ps=7.38u w=7u l=0.7u
X916 VDD.t358 a_1220_1772# Vop.t106 VDD.t1 sg13_lv_pmos ad=0.2603p pd=1.75u as=0.2603p ps=1.75u w=1.37u l=0.35u
X917 a_36_n4396# VREF.t0 a_n2002_n4396# VDD.t0 sg13_lv_pmos ad=0.24415p pd=1.665u as=0.24415p ps=1.665u w=1.285u l=0.35u
X918 Von.t144 a_n10106_3341# VDD.t156 VDD.t1 sg13_lv_pmos ad=0.2603p pd=1.75u as=0.2603p ps=1.75u w=1.37u l=0.35u
X919 Vop.t32 a_1220_1772# VDD.t574 VDD.t1 sg13_lv_pmos ad=0.2603p pd=1.75u as=0.2603p ps=1.75u w=1.37u l=0.35u
X920 Vop.t19 a_n10179_n275# VSS.t95 VSS.t61 sg13_lv_nmos ad=0.912p pd=5.18u as=1.632p ps=10.28u w=4.8u l=1.06u
X921 VOUTN.t16 a_n20570_n9414# VDD.t80 VSS.t135 sg13_lv_nmos ad=3.4p pd=20.68u as=3.4p ps=20.68u w=10u l=0.15u
X922 VDD.t394 a_1220_1772# Vop.t121 VDD.t1 sg13_lv_pmos ad=0.2603p pd=1.75u as=0.2603p ps=1.75u w=1.37u l=0.35u
X923 VSS.t298 CMFBout.t30 CMFBout.t36 VSS.t297 sg13_lv_nmos ad=0.6327p pd=3.71u as=0.6327p ps=3.71u w=3.33u l=0.2u
X924 VDD.t360 a_1220_1772# Vop.t50 VDD.t1 sg13_lv_pmos ad=0.2603p pd=1.75u as=0.2603p ps=1.75u w=1.37u l=0.35u
X925 a_36_n4396# VREF.t0 a_n2002_n4396# VDD.t0 sg13_lv_pmos ad=0.24415p pd=1.665u as=0.24415p ps=1.665u w=1.285u l=0.35u
X926 VSS.t41 a_n10179_n275# Von.t19 VSS.t14 sg13_lv_nmos ad=0.912p pd=5.18u as=0.912p ps=5.18u w=4.8u l=1.06u
X927 Von.t29 a_n10179_n275# VSS.t18 VSS.t19 sg13_lv_nmos ad=0.912p pd=5.18u as=0.912p ps=5.18u w=4.8u l=1.06u
X928 VDD.t881 a_n6543_n10895# a_n2002_n4396# VDD.t0 sg13_lv_pmos ad=0.19p pd=1.38u as=0.19p ps=1.38u w=1u l=0.7u
X929 VDD.t122 a_n10106_3341# Von.t33 VDD.t1 sg13_lv_pmos ad=0.2603p pd=1.75u as=0.2603p ps=1.75u w=1.37u l=0.35u
X930 Vop.t47 a_1220_1772# VDD.t347 VDD.t1 sg13_lv_pmos ad=0.2603p pd=1.75u as=0.4658p ps=3.42u w=1.37u l=0.35u
X931 VDD.t178 a_n10106_3341# Von.t154 VDD.t1 sg13_lv_pmos ad=0.2603p pd=1.75u as=0.2603p ps=1.75u w=1.37u l=0.35u
X932 a_36_n4396# VREF.t0 a_n2002_n4396# VDD.t0 sg13_lv_pmos ad=0.4369p pd=3.25u as=0.24415p ps=1.665u w=1.285u l=0.35u
X933 VDD.t150 a_n10106_3341# Von.t108 VDD.t1 sg13_lv_pmos ad=0.2603p pd=1.75u as=0.2603p ps=1.75u w=1.37u l=0.35u
X934 a_11820_n9920# Vop.t157 a_11652_n9920# VSS.t163 sg13_lv_nmos ad=1.9p pd=10.38u as=1.9p ps=10.38u w=10u l=0.5u
X935 VDD.t83 a_n20570_n9414# VOUTN.t1 VSS.t138 sg13_lv_nmos ad=3.4p pd=20.68u as=3.4p ps=20.68u w=10u l=0.15u
X936 VDD.t242 a_n10106_3341# Von.t69 VDD.t1 sg13_lv_pmos ad=0.2603p pd=1.75u as=0.2603p ps=1.75u w=1.37u l=0.35u
X937 VDD.t794 a_n6543_n10895# a_n2002_n4396# VDD.t0 sg13_lv_pmos ad=0.19p pd=1.38u as=0.19p ps=1.38u w=1u l=0.7u
X938 CMFBout.t9 Vop.t158 a_n2002_n4396# VDD.t0 sg13_lv_pmos ad=0.24415p pd=1.665u as=0.24415p ps=1.665u w=1.285u l=0.35u
X939 Von.t23 a_n10179_n275# VSS.t47 VSS.t25 sg13_lv_nmos ad=0.912p pd=5.18u as=0.912p ps=5.18u w=4.8u l=1.06u
X940 VSS.t243 CMFBin.t4 a_n3162_51# VSS.t242 sg13_lv_nmos ad=0.6327p pd=3.71u as=0.6327p ps=3.71u w=3.33u l=0.2u
X941 Vop.t41 a_1220_1772# VDD.t557 VDD.t1 sg13_lv_pmos ad=0.2603p pd=1.75u as=0.4658p ps=3.42u w=1.37u l=0.35u
X942 a_n2373_n10895# a_n6543_n9623# a_n3721_n10895# VSS.t315 sg13_lv_nmos ad=1.14p pd=6.38u as=1.14p ps=6.38u w=6u l=6.4u
X943 Vop.t91 a_1220_1772# VDD.t480 VDD.t1 sg13_lv_pmos ad=0.2603p pd=1.75u as=0.2603p ps=1.75u w=1.37u l=0.35u
X944 VDD.t61 a_n10013_2465# a_881_4136# VDD.t1 sg13_lv_pmos ad=1.33p pd=7.38u as=1.33p ps=7.38u w=7u l=0.7u
X945 VDD.t600 a_13228_n9920# VOUTP.t2 VSS.t170 sg13_lv_nmos ad=3.4p pd=20.68u as=3.4p ps=20.68u w=10u l=0.15u
X946 Vop.t87 a_1220_1772# VDD.t448 VDD.t1 sg13_lv_pmos ad=0.2603p pd=1.75u as=0.2603p ps=1.75u w=1.37u l=0.35u
X947 a_n2002_n4396# a_n6543_n10895# VDD.t968 VDD.t0 sg13_lv_pmos ad=0.19p pd=1.38u as=0.19p ps=1.38u w=1u l=0.7u
X948 VDD.t102 a_n10106_3341# Von.t58 VDD.t1 sg13_lv_pmos ad=0.2603p pd=1.75u as=0.2603p ps=1.75u w=1.37u l=0.35u
X949 a_n5006_n3441# a_n6543_n10895# VDD.t807 VDD.t0 sg13_lv_pmos ad=0.19p pd=1.38u as=0.19p ps=1.38u w=1u l=0.7u
X950 VDD.t430 a_1220_1772# Vop.t99 VDD.t1 sg13_lv_pmos ad=0.2603p pd=1.75u as=0.2603p ps=1.75u w=1.37u l=0.35u
X951 VSS.t204 CMFBin.t17 a_n3162_51# VSS.t203 sg13_lv_nmos ad=0.6327p pd=3.71u as=0.6327p ps=3.71u w=3.33u l=0.2u
X952 Vop.t7 a_n10179_n275# VSS.t120 VSS.t9 sg13_lv_nmos ad=0.912p pd=5.18u as=0.912p ps=5.18u w=4.8u l=1.06u
X953 a_881_4136# a_n9221_n275# a_1220_1772# VDD.t1 sg13_lv_pmos ad=0.7695p pd=4.43u as=0.7695p ps=4.43u w=4.05u l=0.5u
X954 VDD.t156 a_n10106_3341# Von.t147 VDD.t1 sg13_lv_pmos ad=0.2603p pd=1.75u as=0.2603p ps=1.75u w=1.37u l=0.35u
X955 VSS.t339 a_36_n4396# a_36_n4396# VSS.t338 sg13_lv_nmos ad=0.6327p pd=3.71u as=0.6327p ps=3.71u w=3.33u l=0.2u
X956 VDD.t566 a_1220_1772# Vop.t36 VDD.t1 sg13_lv_pmos ad=0.4658p pd=3.42u as=0.2603p ps=1.75u w=1.37u l=0.35u
X957 a_n3381_1772# a_n10013_2465# VDD.t37 VDD.t1 sg13_lv_pmos ad=1.33p pd=7.38u as=1.33p ps=7.38u w=7u l=0.7u
X958 a_n10106_3341# a_n9221_n275# a_n3381_1772# VDD.t1 sg13_lv_pmos ad=0.7695p pd=4.43u as=0.7695p ps=4.43u w=4.05u l=0.5u
X959 VDD.t220 a_n10106_3341# Von.t86 VDD.t1 sg13_lv_pmos ad=0.2603p pd=1.75u as=0.2603p ps=1.75u w=1.37u l=0.35u
X960 VDD.t192 a_n10106_3341# Von.t93 VDD.t1 sg13_lv_pmos ad=0.2603p pd=1.75u as=0.2603p ps=1.75u w=1.37u l=0.35u
X961 VDD.t869 a_n6543_n10895# a_n2002_n4396# VDD.t0 sg13_lv_pmos ad=0.19p pd=1.38u as=0.19p ps=1.38u w=1u l=0.7u
X962 VDD.t754 a_n6543_n10895# a_n5006_n3441# VDD.t0 sg13_lv_pmos ad=0.19p pd=1.38u as=0.19p ps=1.38u w=1u l=0.7u
X963 a_n2002_n4396# Vop.t158 CMFBout.t12 VDD.t0 sg13_lv_pmos ad=0.24415p pd=1.665u as=0.24415p ps=1.665u w=1.285u l=0.35u
X964 Von.t24 a_n10179_n275# VSS.t28 VSS.t13 sg13_lv_nmos ad=0.912p pd=5.18u as=0.912p ps=5.18u w=4.8u l=1.06u
X965 a_286_1773# a_n8929_2739# a_1220_1772# VSS.t333 sg13_lv_nmos ad=0.646p pd=4.48u as=0.361p ps=2.28u w=1.9u l=0.16u
X966 a_13228_n9920# VOUTP.t26 a_11652_n9920# VSS.t2 sg13_lv_nmos ad=1.9p pd=10.38u as=1.9p ps=10.38u w=10u l=0.5u
X967 VDD.t304 a_n10106_3341# Von.t122 VDD.t1 sg13_lv_pmos ad=0.4658p pd=3.42u as=0.2603p ps=1.75u w=1.37u l=0.35u
X968 a_n5006_n3441# a_n6543_n10895# VDD.t653 VDD.t0 sg13_lv_pmos ad=0.19p pd=1.38u as=0.34p ps=2.68u w=1u l=0.7u
X969 Von.t65 a_n10106_3341# VDD.t335 VDD.t1 sg13_lv_pmos ad=0.2603p pd=1.75u as=0.4658p ps=3.42u w=1.37u l=0.35u
X970 VDD.t966 a_n6543_n10895# a_n2002_n4396# VDD.t0 sg13_lv_pmos ad=0.19p pd=1.38u as=0.19p ps=1.38u w=1u l=0.7u
X971 a_n14155_n5285# Von.t157 a_n14528_n9920# VSS.t305 sg13_lv_nmos ad=1.9p pd=10.38u as=1.9p ps=10.38u w=10u l=0.5u
X972 a_36_n4396# VREF.t0 a_n5006_n3441# VDD.t0 sg13_lv_pmos ad=0.24415p pd=1.665u as=0.24415p ps=1.665u w=1.285u l=0.35u
X973 a_881_4136# a_n10013_2465# VDD.t52 VDD.t1 sg13_lv_pmos ad=1.33p pd=7.38u as=2.38p ps=14.68u w=7u l=0.7u
X974 VDD.t412 a_1220_1772# Vop.t94 VDD.t1 sg13_lv_pmos ad=0.2603p pd=1.75u as=0.2603p ps=1.75u w=1.37u l=0.35u
X975 VSS.t36 a_n10179_n275# Von.t15 VSS.t23 sg13_lv_nmos ad=0.912p pd=5.18u as=0.912p ps=5.18u w=4.8u l=1.06u
X976 Vop.t66 a_1220_1772# VDD.t518 VDD.t1 sg13_lv_pmos ad=0.2603p pd=1.75u as=0.2603p ps=1.75u w=1.37u l=0.35u
X977 a_n1828_1772# a_n8929_2739# a_n10106_3341# VSS.t323 sg13_lv_nmos ad=0.361p pd=2.28u as=0.361p ps=2.28u w=1.9u l=0.16u
X978 a_n2002_n4396# Vop.t158 CMFBout.t11 VDD.t0 sg13_lv_pmos ad=0.24415p pd=1.665u as=0.24415p ps=1.665u w=1.285u l=0.35u
X979 Von.t154 a_n10106_3341# VDD.t176 VDD.t1 sg13_lv_pmos ad=0.2603p pd=1.75u as=0.2603p ps=1.75u w=1.37u l=0.35u
X980 Vop.t128 a_1220_1772# VDD.t594 VDD.t1 sg13_lv_pmos ad=0.2603p pd=1.75u as=0.2603p ps=1.75u w=1.37u l=0.35u
X981 a_286_1773# a_n8929_2739# a_1220_1772# VSS.t333 sg13_lv_nmos ad=0.646p pd=4.48u as=0.361p ps=2.28u w=1.9u l=0.16u
X982 a_11820_n9920# Vop.t157 a_11652_n9920# VSS.t157 sg13_lv_nmos ad=1.9p pd=10.38u as=3.4p ps=20.68u w=10u l=0.5u
X983 Von.t108 a_n10106_3341# VDD.t148 VDD.t1 sg13_lv_pmos ad=0.2603p pd=1.75u as=0.2603p ps=1.75u w=1.37u l=0.35u
X984 VDD.t558 a_1220_1772# Vop.t41 VDD.t1 sg13_lv_pmos ad=0.2603p pd=1.75u as=0.2603p ps=1.75u w=1.37u l=0.35u
X985 a_n2002_n4396# a_n6543_n10895# VDD.t798 VDD.t0 sg13_lv_pmos ad=0.19p pd=1.38u as=0.19p ps=1.38u w=1u l=0.7u
X986 a_n2002_n4396# a_n6543_n10895# VDD.t784 VDD.t0 sg13_lv_pmos ad=0.19p pd=1.38u as=0.19p ps=1.38u w=1u l=0.7u
X987 a_881_4136# a_n9221_n275# a_1220_1772# VDD.t1 sg13_lv_pmos ad=0.7695p pd=4.43u as=0.7695p ps=4.43u w=4.05u l=0.5u
X988 a_n3381_1772# a_n10013_2465# VDD.t9 VDD.t1 sg13_lv_pmos ad=1.33p pd=7.38u as=1.33p ps=7.38u w=7u l=0.7u
X989 a_11820_n9920# a_11820_n9920# VDD.t636 VDD.t633 sg13_lv_pmos ad=1.9p pd=10.38u as=3.4p ps=20.68u w=10u l=1u
X990 a_n6543_n10895# a_n6543_n10895# VDD.t671 VDD.t0 sg13_lv_pmos ad=0.19p pd=1.38u as=0.19p ps=1.38u w=1u l=0.7u
X991 VDD.t254 a_n10106_3341# Von.t98 VDD.t1 sg13_lv_pmos ad=0.4658p pd=3.42u as=0.2603p ps=1.75u w=1.37u l=0.35u
X992 a_n2002_n4396# a_n6543_n10895# VDD.t920 VDD.t0 sg13_lv_pmos ad=0.19p pd=1.38u as=0.19p ps=1.38u w=1u l=0.7u
X993 VDD.t90 a_n20570_n9414# VOUTN.t23 VSS.t136 sg13_lv_nmos ad=3.4p pd=20.68u as=3.4p ps=20.68u w=10u l=0.15u
X994 a_n10106_3341# a_n9221_n275# a_n3381_1772# VDD.t1 sg13_lv_pmos ad=0.7695p pd=4.43u as=0.7695p ps=4.43u w=4.05u l=0.5u
X995 VDD.t800 a_n6543_n10895# a_n2002_n4396# VDD.t0 sg13_lv_pmos ad=0.34p pd=2.68u as=0.19p ps=1.38u w=1u l=0.7u
X996 VDD.t804 a_n6543_n10895# a_n5006_n3441# VDD.t0 sg13_lv_pmos ad=0.19p pd=1.38u as=0.19p ps=1.38u w=1u l=0.7u
X997 VSS.t106 a_n10179_n275# Von.t28 VSS.t26 sg13_lv_nmos ad=1.632p pd=10.28u as=0.912p ps=5.18u w=4.8u l=1.06u
X998 CMFBout.t26 Von.t158 a_n5006_n3441# VDD.t0 sg13_lv_pmos ad=0.24415p pd=1.665u as=0.24415p ps=1.665u w=1.285u l=0.35u
X999 CMFBout.t15 Vop.t158 a_n2002_n4396# VDD.t0 sg13_lv_pmos ad=0.4369p pd=3.25u as=0.24415p ps=1.665u w=1.285u l=0.35u
X1000 VSS.t68 a_n10179_n275# Vop.t26 VSS.t9 sg13_lv_nmos ad=0.912p pd=5.18u as=0.912p ps=5.18u w=4.8u l=1.06u
X1001 a_n5006_n3441# VREF.t0 a_36_n4396# VDD.t0 sg13_lv_pmos ad=0.24415p pd=1.665u as=0.24415p ps=1.665u w=1.285u l=0.35u
X1002 Von.t125 a_n10106_3341# VDD.t290 VDD.t1 sg13_lv_pmos ad=0.2603p pd=1.75u as=0.2603p ps=1.75u w=1.37u l=0.35u
X1003 a_881_4136# a_n9221_n275# a_1220_1772# VDD.t1 sg13_lv_pmos ad=0.7695p pd=4.43u as=0.7695p ps=4.43u w=4.05u l=0.5u
X1004 VDD.t45 a_n10013_2465# a_881_4136# VDD.t1 sg13_lv_pmos ad=2.38p pd=14.68u as=1.33p ps=7.38u w=7u l=0.7u
X1005 Vop.t38 a_1220_1772# VDD.t577 VDD.t1 sg13_lv_pmos ad=0.2603p pd=1.75u as=0.4658p ps=3.42u w=1.37u l=0.35u
X1006 Von.t86 a_n10106_3341# VDD.t218 VDD.t1 sg13_lv_pmos ad=0.2603p pd=1.75u as=0.2603p ps=1.75u w=1.37u l=0.35u
X1007 VDD.t701 a_n6543_n10895# a_n6543_n10895# VDD.t0 sg13_lv_pmos ad=0.19p pd=1.38u as=0.19p ps=1.38u w=1u l=0.7u
X1008 VDD.t610 a_13228_n9920# VOUTP.t21 VSS.t172 sg13_lv_nmos ad=3.4p pd=20.68u as=3.4p ps=20.68u w=10u l=0.15u
X1009 VDD.t79 a_n20570_n9414# VOUTN.t21 VSS.t134 sg13_lv_nmos ad=3.4p pd=20.68u as=3.4p ps=20.68u w=10u l=0.15u
X1010 VDD.t687 a_n6543_n10895# a_n6543_n10895# VDD.t0 sg13_lv_pmos ad=0.19p pd=1.38u as=0.19p ps=1.38u w=1u l=0.7u
X1011 VDD.t918 a_n6543_n10895# a_n2002_n4396# VDD.t0 sg13_lv_pmos ad=0.19p pd=1.38u as=0.19p ps=1.38u w=1u l=0.7u
X1012 a_11820_n9920# Vop.t157 a_11652_n9920# VSS.t159 sg13_lv_nmos ad=1.9p pd=10.38u as=1.9p ps=10.38u w=10u l=0.5u
X1013 a_1220_1772# a_n9221_n275# a_881_4136# VDD.t1 sg13_lv_pmos ad=0.7695p pd=4.43u as=0.7695p ps=4.43u w=4.05u l=0.5u
X1014 VDD.t954 a_n6543_n10895# a_n5006_n3441# VDD.t0 sg13_lv_pmos ad=0.19p pd=1.38u as=0.19p ps=1.38u w=1u l=0.7u
X1015 Vop.t95 a_1220_1772# VDD.t412 VDD.t1 sg13_lv_pmos ad=0.2603p pd=1.75u as=0.2603p ps=1.75u w=1.37u l=0.35u
X1016 a_n10106_3341# a_n9221_n275# a_n3381_1772# VDD.t1 sg13_lv_pmos ad=0.7695p pd=4.43u as=0.7695p ps=4.43u w=4.05u l=0.5u
X1017 VDD.t34 a_n10013_2465# a_n10013_2465# VDD.t1 sg13_lv_pmos ad=0.476p pd=3.48u as=0.266p ps=1.78u w=1.4u l=0.35u
X1018 a_13228_n9920# VOUTP.t26 a_11652_n9920# VSS.t4 sg13_lv_nmos ad=1.9p pd=10.38u as=1.9p ps=10.38u w=10u l=0.5u
X1019 a_n2002_n4396# a_n6543_n10895# VDD.t735 VDD.t0 sg13_lv_pmos ad=0.19p pd=1.38u as=0.19p ps=1.38u w=1u l=0.7u
X1020 a_n3381_1772# a_n9221_n275# a_n10106_3341# VDD.t1 sg13_lv_pmos ad=0.7695p pd=4.43u as=0.7695p ps=4.43u w=4.05u l=0.5u
X1021 VDD.t176 a_n10106_3341# Von.t153 VDD.t1 sg13_lv_pmos ad=0.2603p pd=1.75u as=0.2603p ps=1.75u w=1.37u l=0.35u
X1022 VDD.t148 a_n10106_3341# Von.t112 VDD.t1 sg13_lv_pmos ad=0.2603p pd=1.75u as=0.2603p ps=1.75u w=1.37u l=0.35u
X1023 VDD.t586 a_1220_1772# Vop.t152 VDD.t1 sg13_lv_pmos ad=0.4658p pd=3.42u as=0.2603p ps=1.75u w=1.37u l=0.35u
X1024 VDD.t324 a_n10106_3341# Von.t130 VDD.t1 sg13_lv_pmos ad=0.4658p pd=3.42u as=0.2603p ps=1.75u w=1.37u l=0.35u
X1025 Von.t42 a_n10106_3341# VDD.t260 VDD.t1 sg13_lv_pmos ad=0.2603p pd=1.75u as=0.2603p ps=1.75u w=1.37u l=0.35u
X1026 a_36_n4396# VREF.t0 a_n2002_n4396# VDD.t0 sg13_lv_pmos ad=0.24415p pd=1.665u as=0.24415p ps=1.665u w=1.285u l=0.35u
X1027 VOUTP.t13 a_13228_n9920# VDD.t607 VSS.t169 sg13_lv_nmos ad=3.4p pd=20.68u as=3.4p ps=20.68u w=10u l=0.15u
X1028 VDD.t240 a_n10106_3341# Von.t75 VDD.t1 sg13_lv_pmos ad=0.2603p pd=1.75u as=0.2603p ps=1.75u w=1.37u l=0.35u
X1029 a_n10106_3341# a_n8929_2739# a_n1828_1772# VSS.t324 sg13_lv_nmos ad=0.361p pd=2.28u as=0.361p ps=2.28u w=1.9u l=0.16u
X1030 VDD.t960 a_n6543_n10895# a_n5006_n3441# VDD.t0 sg13_lv_pmos ad=0.19p pd=1.38u as=0.19p ps=1.38u w=1u l=0.7u
X1031 VDD.t212 a_n10106_3341# Von.t81 VDD.t1 sg13_lv_pmos ad=0.2603p pd=1.75u as=0.2603p ps=1.75u w=1.37u l=0.35u
X1032 Von.t152 a_n10106_3341# VDD.t172 VDD.t1 sg13_lv_pmos ad=0.2603p pd=1.75u as=0.2603p ps=1.75u w=1.37u l=0.35u
X1033 a_n3162_51# VNin.t0 a_286_1773# VSS.t147 sg13_lv_nmos ad=0.374p pd=2.88u as=0.209p ps=1.48u w=1.1u l=0.15u
X1034 a_286_1773# a_n8929_2739# a_1220_1772# VSS.t329 sg13_lv_nmos ad=0.361p pd=2.28u as=0.361p ps=2.28u w=1.9u l=0.16u
X1035 VDD.t757 a_n6543_n10895# a_n5006_n3441# VDD.t0 sg13_lv_pmos ad=0.19p pd=1.38u as=0.19p ps=1.38u w=1u l=0.7u
X1036 Vop.t21 a_n10179_n275# VSS.t113 VSS.t9 sg13_lv_nmos ad=0.912p pd=5.18u as=0.912p ps=5.18u w=4.8u l=1.06u
X1037 a_n3162_51# CMFBin.t1 VSS.t252 VSS.t253 sg13_lv_nmos ad=0.6327p pd=3.71u as=0.6327p ps=3.71u w=3.33u l=0.2u
X1038 a_n2002_n4396# a_n6543_n10895# VDD.t980 VDD.t0 sg13_lv_pmos ad=0.19p pd=1.38u as=0.19p ps=1.38u w=1u l=0.7u
X1039 VDD.t733 a_n6543_n10895# a_n2002_n4396# VDD.t0 sg13_lv_pmos ad=0.19p pd=1.38u as=0.19p ps=1.38u w=1u l=0.7u
X1040 Vop.t88 a_1220_1772# VDD.t450 VDD.t1 sg13_lv_pmos ad=0.2603p pd=1.75u as=0.2603p ps=1.75u w=1.37u l=0.35u
X1041 VDD.t432 a_1220_1772# Vop.t100 VDD.t1 sg13_lv_pmos ad=0.2603p pd=1.75u as=0.2603p ps=1.75u w=1.37u l=0.35u
X1042 VDD.t384 a_1220_1772# Vop.t107 VDD.t1 sg13_lv_pmos ad=0.2603p pd=1.75u as=0.2603p ps=1.75u w=1.37u l=0.35u
X1043 VDD.t400 a_1220_1772# Vop.t117 VDD.t1 sg13_lv_pmos ad=0.2603p pd=1.75u as=0.2603p ps=1.75u w=1.37u l=0.35u
X1044 VSS.t107 a_n10179_n275# Vop.t19 VSS.t63 sg13_lv_nmos ad=0.912p pd=5.18u as=0.912p ps=5.18u w=4.8u l=1.06u
X1045 a_286_1773# VNin.t0 a_n3162_51# VSS.t146 sg13_lv_nmos ad=0.209p pd=1.48u as=0.209p ps=1.48u w=1.1u l=0.15u
X1046 a_n3162_51# CMFBin.t21 VSS.t192 VSS.t193 sg13_lv_nmos ad=0.6327p pd=3.71u as=0.6327p ps=3.71u w=3.33u l=0.2u
X1047 a_13228_n9920# VOUTP.t26 a_11652_n9920# VSS.t6 sg13_lv_nmos ad=1.9p pd=10.38u as=1.9p ps=10.38u w=10u l=0.5u
X1048 VDD.t578 a_1220_1772# Vop.t38 VDD.t1 sg13_lv_pmos ad=0.2603p pd=1.75u as=0.2603p ps=1.75u w=1.37u l=0.35u
X1049 VDD.t218 a_n10106_3341# Von.t85 VDD.t1 sg13_lv_pmos ad=0.2603p pd=1.75u as=0.2603p ps=1.75u w=1.37u l=0.35u
X1050 a_n1828_1772# VPin.t0 a_n3162_51# VSS.t149 sg13_lv_nmos ad=0.209p pd=1.48u as=0.374p ps=2.88u w=1.1u l=0.15u
X1051 VDD.t190 a_n10106_3341# Von.t142 VDD.t1 sg13_lv_pmos ad=0.2603p pd=1.75u as=0.2603p ps=1.75u w=1.37u l=0.35u
X1052 Vop.t12 a_n10179_n275# VSS.t75 VSS.t9 sg13_lv_nmos ad=0.912p pd=5.18u as=0.912p ps=5.18u w=4.8u l=1.06u
X1053 a_n14155_n5285# Von.t157 a_n14528_n9920# VSS.t301 sg13_lv_nmos ad=1.9p pd=10.38u as=1.9p ps=10.38u w=10u l=0.5u
X1054 Von.t19 a_n10179_n275# VSS.t39 VSS.t13 sg13_lv_nmos ad=0.912p pd=5.18u as=0.912p ps=5.18u w=4.8u l=1.06u
X1055 VSS.t18 a_n10179_n275# Von.t13 VSS.t17 sg13_lv_nmos ad=0.912p pd=5.18u as=0.912p ps=5.18u w=4.8u l=1.06u
X1056 VSS.t286 CMFBout.t30 CMFBout.t38 VSS.t285 sg13_lv_nmos ad=0.6327p pd=3.71u as=1.1322p ps=7.34u w=3.33u l=0.2u
X1057 Von.t117 a_n10106_3341# VDD.t112 VDD.t1 sg13_lv_pmos ad=0.2603p pd=1.75u as=0.2603p ps=1.75u w=1.37u l=0.35u
X1058 VDD.t906 a_n6543_n10895# a_n5006_n3441# VDD.t0 sg13_lv_pmos ad=0.19p pd=1.38u as=0.19p ps=1.38u w=1u l=0.7u
X1059 a_n14528_n9920# Von.t157 a_n14155_n5285# VSS.t307 sg13_lv_nmos ad=3.4p pd=20.68u as=1.9p ps=10.38u w=10u l=0.5u
X1060 a_n5006_n3441# Von.t158 CMFBout.t20 VDD.t0 sg13_lv_pmos ad=0.24415p pd=1.665u as=0.24415p ps=1.665u w=1.285u l=0.35u
X1061 a_n5006_n3441# a_n6543_n10895# VDD.t855 VDD.t0 sg13_lv_pmos ad=0.19p pd=1.38u as=0.19p ps=1.38u w=1u l=0.7u
X1062 VDD.t657 a_n6543_n10895# a_n2002_n4396# VDD.t0 sg13_lv_pmos ad=0.19p pd=1.38u as=0.19p ps=1.38u w=1u l=0.7u
X1063 Von.t123 a_n10106_3341# VDD.t305 VDD.t1 sg13_lv_pmos ad=0.2603p pd=1.75u as=0.4658p ps=3.42u w=1.37u l=0.35u
X1064 a_11820_n9920# Vop.t157 a_11652_n9920# VSS.t161 sg13_lv_nmos ad=1.9p pd=10.38u as=1.9p ps=10.38u w=10u l=0.5u
X1065 a_n6543_n10895# a_n6543_n10895# VDD.t691 VDD.t0 sg13_lv_pmos ad=0.19p pd=1.38u as=0.19p ps=1.38u w=1u l=0.7u
X1066 VDD.t414 a_1220_1772# Vop.t95 VDD.t1 sg13_lv_pmos ad=0.2603p pd=1.75u as=0.2603p ps=1.75u w=1.37u l=0.35u
X1067 a_n10013_2465# a_n10013_2465# VDD.t32 VDD.t1 sg13_lv_pmos ad=0.266p pd=1.78u as=0.266p ps=1.78u w=1.4u l=0.35u
X1068 VSS.t47 a_n10179_n275# Von.t22 VSS.t23 sg13_lv_nmos ad=0.912p pd=5.18u as=0.912p ps=5.18u w=4.8u l=1.06u
X1069 a_n5006_n3441# a_n6543_n10895# VDD.t948 VDD.t0 sg13_lv_pmos ad=0.19p pd=1.38u as=0.19p ps=1.38u w=1u l=0.7u
X1070 Vop.t67 a_1220_1772# VDD.t520 VDD.t1 sg13_lv_pmos ad=0.2603p pd=1.75u as=0.2603p ps=1.75u w=1.37u l=0.35u
X1071 VDD.t912 a_n6543_n10895# a_n5006_n3441# VDD.t0 sg13_lv_pmos ad=0.19p pd=1.38u as=0.19p ps=1.38u w=1u l=0.7u
X1072 VDD.t470 a_1220_1772# Vop.t72 VDD.t1 sg13_lv_pmos ad=0.2603p pd=1.75u as=0.2603p ps=1.75u w=1.37u l=0.35u
X1073 Von.t112 a_n10106_3341# VDD.t146 VDD.t1 sg13_lv_pmos ad=0.2603p pd=1.75u as=0.2603p ps=1.75u w=1.37u l=0.35u
X1074 a_n1828_1772# a_n8929_2739# a_n10106_3341# VSS.t325 sg13_lv_nmos ad=0.361p pd=2.28u as=0.361p ps=2.28u w=1.9u l=0.16u
X1075 Vop.t36 a_1220_1772# VDD.t564 VDD.t1 sg13_lv_pmos ad=0.2603p pd=1.75u as=0.2603p ps=1.75u w=1.37u l=0.35u
X1076 VSS.t177 CMFBin.t26 a_n3162_51# VSS.t176 sg13_lv_nmos ad=0.6327p pd=3.71u as=1.1322p ps=7.34u w=3.33u l=0.2u
X1077 a_36_n4396# VREF.t0 a_n5006_n3441# VDD.t0 sg13_lv_pmos ad=0.24415p pd=1.665u as=0.24415p ps=1.665u w=1.285u l=0.35u
X1078 a_286_1773# VNin.t0 a_n3162_51# VSS.t146 sg13_lv_nmos ad=0.209p pd=1.48u as=0.209p ps=1.48u w=1.1u l=0.15u
X1079 a_n6543_n10895# a_n6543_n10895# VDD.t659 VDD.t0 sg13_lv_pmos ad=0.19p pd=1.38u as=0.19p ps=1.38u w=1u l=0.7u
X1080 a_n5006_n3441# Von.t158 CMFBout.t16 VDD.t0 sg13_lv_pmos ad=0.24415p pd=1.665u as=0.4369p ps=3.25u w=1.285u l=0.35u
X1081 VSS.t130 a_n10179_n275# Vop.t9 VSS.t9 sg13_lv_nmos ad=0.912p pd=5.18u as=0.912p ps=5.18u w=4.8u l=1.06u
X1082 a_1220_1772# a_n8929_2739# a_286_1773# VSS.t328 sg13_lv_nmos ad=0.361p pd=2.28u as=0.646p ps=4.48u w=1.9u l=0.16u
X1083 a_n3162_51# VNin.t0 a_286_1773# VSS.t147 sg13_lv_nmos ad=0.374p pd=2.88u as=0.209p ps=1.48u w=1.1u l=0.15u
X1084 VSS.t28 a_n10179_n275# Von.t27 VSS.t11 sg13_lv_nmos ad=0.912p pd=5.18u as=1.632p ps=10.28u w=4.8u l=1.06u
X1085 Von.t75 a_n10106_3341# VDD.t238 VDD.t1 sg13_lv_pmos ad=0.2603p pd=1.75u as=0.2603p ps=1.75u w=1.37u l=0.35u
X1086 a_n2002_n4396# a_n6543_n10895# VDD.t933 VDD.t0 sg13_lv_pmos ad=0.19p pd=1.38u as=0.19p ps=1.38u w=1u l=0.7u
X1087 a_n5006_n3441# VREF.t0 a_36_n4396# VDD.t0 sg13_lv_pmos ad=0.24415p pd=1.665u as=0.24415p ps=1.665u w=1.285u l=0.35u
X1088 VDD.t889 a_n6543_n10895# a_n2002_n4396# VDD.t0 sg13_lv_pmos ad=0.19p pd=1.38u as=0.19p ps=1.38u w=1u l=0.7u
X1089 VDD.t719 a_n6543_n10895# a_n5006_n3441# VDD.t0 sg13_lv_pmos ad=0.19p pd=1.38u as=0.19p ps=1.38u w=1u l=0.7u
X1090 Vop.t103 a_1220_1772# VDD.t432 VDD.t1 sg13_lv_pmos ad=0.2603p pd=1.75u as=0.2603p ps=1.75u w=1.37u l=0.35u
X1091 VDD.t958 a_n6543_n10895# a_n5006_n3441# VDD.t0 sg13_lv_pmos ad=0.19p pd=1.38u as=0.19p ps=1.38u w=1u l=0.7u
X1092 VOUTN.t17 a_n20570_n9414# VDD.t87 VSS.t133 sg13_lv_nmos ad=3.4p pd=20.68u as=3.4p ps=20.68u w=10u l=0.15u
X1093 VDD.t344 a_n10106_3341# Von.t139 VDD.t1 sg13_lv_pmos ad=0.4658p pd=3.42u as=0.2603p ps=1.75u w=1.37u l=0.35u
X1094 VDD.t788 a_n6543_n10895# a_n2002_n4396# VDD.t0 sg13_lv_pmos ad=0.19p pd=1.38u as=0.19p ps=1.38u w=1u l=0.7u
X1095 VDD.t725 a_n6543_n10895# a_n5006_n3441# VDD.t0 sg13_lv_pmos ad=0.19p pd=1.38u as=0.19p ps=1.38u w=1u l=0.7u
X1096 VDD.t232 a_n10106_3341# Von.t77 VDD.t1 sg13_lv_pmos ad=0.2603p pd=1.75u as=0.2603p ps=1.75u w=1.37u l=0.35u
X1097 Vop.t50 a_1220_1772# VDD.t358 VDD.t1 sg13_lv_pmos ad=0.2603p pd=1.75u as=0.2603p ps=1.75u w=1.37u l=0.35u
X1098 a_n2002_n4396# VREF.t0 a_36_n4396# VDD.t0 sg13_lv_pmos ad=0.24415p pd=1.665u as=0.24415p ps=1.665u w=1.285u l=0.35u
X1099 VDD.t825 a_n6543_n10895# a_n2002_n4396# VDD.t0 sg13_lv_pmos ad=0.19p pd=1.38u as=0.19p ps=1.38u w=1u l=0.7u
X1100 a_n3162_51# VPin.t0 a_n1828_1772# VSS.t150 sg13_lv_nmos ad=0.209p pd=1.48u as=0.209p ps=1.48u w=1.1u l=0.15u
X1101 a_n1828_1772# VPin.t0 a_n3162_51# VSS.t149 sg13_lv_nmos ad=0.209p pd=1.48u as=0.374p ps=2.88u w=1.1u l=0.15u
X1102 a_n2002_n4396# a_n6543_n10895# VDD.t747 VDD.t0 sg13_lv_pmos ad=0.19p pd=1.38u as=0.19p ps=1.38u w=1u l=0.7u
X1103 VDD.t51 a_n10013_2465# a_881_4136# VDD.t1 sg13_lv_pmos ad=2.38p pd=14.68u as=1.33p ps=7.38u w=7u l=0.7u
X1104 a_n2002_n4396# a_n6543_n10895# VDD.t976 VDD.t0 sg13_lv_pmos ad=0.19p pd=1.38u as=0.19p ps=1.38u w=1u l=0.7u
X1105 Von.t85 a_n10106_3341# VDD.t216 VDD.t1 sg13_lv_pmos ad=0.2603p pd=1.75u as=0.2603p ps=1.75u w=1.37u l=0.35u
X1106 a_n5006_n3441# a_n6543_n10895# VDD.t801 VDD.t0 sg13_lv_pmos ad=0.19p pd=1.38u as=0.34p ps=2.68u w=1u l=0.7u
X1107 VDD.t689 a_n6543_n10895# a_n6543_n10895# VDD.t0 sg13_lv_pmos ad=0.19p pd=1.38u as=0.19p ps=1.38u w=1u l=0.7u
X1108 VOUTP.t16 a_13228_n9920# VDD.t611 VSS.t173 sg13_lv_nmos ad=3.4p pd=20.68u as=3.4p ps=20.68u w=10u l=0.15u
X1109 Von.t15 a_n10179_n275# VSS.t34 VSS.t22 sg13_lv_nmos ad=0.912p pd=5.18u as=0.912p ps=5.18u w=4.8u l=1.06u
X1110 Von.t142 a_n10106_3341# VDD.t188 VDD.t1 sg13_lv_pmos ad=0.2603p pd=1.75u as=0.2603p ps=1.75u w=1.37u l=0.35u
X1111 a_286_1773# VNin.t0 a_n3162_51# VSS.t144 sg13_lv_nmos ad=0.209p pd=1.48u as=0.209p ps=1.48u w=1.1u l=0.15u
X1112 a_881_4136# a_n10013_2465# VDD.t43 VDD.t1 sg13_lv_pmos ad=1.33p pd=7.38u as=1.33p ps=7.38u w=7u l=0.7u
X1113 VDD.t32 a_n10013_2465# a_n10013_2465# VDD.t1 sg13_lv_pmos ad=0.266p pd=1.78u as=0.266p ps=1.78u w=1.4u l=0.35u
X1114 VDD.t116 a_n10106_3341# Von.t113 VDD.t1 sg13_lv_pmos ad=0.2603p pd=1.75u as=0.2603p ps=1.75u w=1.37u l=0.35u
X1115 VDD.t623 a_n3721_n10895# a_n3721_n10895# VDD.t622 sg13_lv_pmos ad=1.14p pd=6.38u as=1.14p ps=6.38u w=6u l=2.5u
X1116 a_n5006_n3441# a_n6543_n10895# VDD.t900 VDD.t0 sg13_lv_pmos ad=0.19p pd=1.38u as=0.19p ps=1.38u w=1u l=0.7u
X1117 VDD.t146 a_n10106_3341# Von.t111 VDD.t1 sg13_lv_pmos ad=0.2603p pd=1.75u as=0.2603p ps=1.75u w=1.37u l=0.35u
X1118 VDD.t238 a_n10106_3341# Von.t74 VDD.t1 sg13_lv_pmos ad=0.2603p pd=1.75u as=0.2603p ps=1.75u w=1.37u l=0.35u
X1119 a_n13845_n10915# a_n3721_n10895# VDD.t628 VDD.t622 sg13_lv_pmos ad=1.14p pd=6.38u as=1.14p ps=6.38u w=6u l=2.5u
X1120 VDD.t210 a_n10106_3341# Von.t105 VDD.t1 sg13_lv_pmos ad=0.2603p pd=1.75u as=0.2603p ps=1.75u w=1.37u l=0.35u
X1121 a_n10106_3341# a_n8929_2739# a_n1828_1772# VSS.t326 sg13_lv_nmos ad=0.361p pd=2.28u as=0.361p ps=2.28u w=1.9u l=0.16u
X1122 VDD.t769 a_n6543_n10895# a_n5006_n3441# VDD.t0 sg13_lv_pmos ad=0.19p pd=1.38u as=0.19p ps=1.38u w=1u l=0.7u
X1123 a_n6543_n10895# a_n6543_n10895# VDD.t681 VDD.t0 sg13_lv_pmos ad=0.19p pd=1.38u as=0.19p ps=1.38u w=1u l=0.7u
X1124 Von.t56 a_n10106_3341# VDD.t142 VDD.t1 sg13_lv_pmos ad=0.2603p pd=1.75u as=0.2603p ps=1.75u w=1.37u l=0.35u
X1125 VSS.t277 IB.t1 a_11652_n9920# VSS.t276 sg13_lv_nmos ad=0.57p pd=3.38u as=0.57p ps=3.38u w=3u l=1u
X1126 Vop.t136 a_1220_1772# VDD.t538 VDD.t1 sg13_lv_pmos ad=0.2603p pd=1.75u as=0.2603p ps=1.75u w=1.37u l=0.35u
X1127 VDD.t368 a_1220_1772# Vop.t49 VDD.t1 sg13_lv_pmos ad=0.2603p pd=1.75u as=0.2603p ps=1.75u w=1.37u l=0.35u
X1128 VDD.t910 a_n6543_n10895# a_n5006_n3441# VDD.t0 sg13_lv_pmos ad=0.19p pd=1.38u as=0.19p ps=1.38u w=1u l=0.7u
X1129 Von.t9 a_n10179_n275# VSS.t100 VSS.t19 sg13_lv_nmos ad=0.912p pd=5.18u as=0.912p ps=5.18u w=4.8u l=1.06u
X1130 Von.t137 a_n10106_3341# VDD.t325 VDD.t1 sg13_lv_pmos ad=0.2603p pd=1.75u as=0.4658p ps=3.42u w=1.37u l=0.35u
X1131 VDD.t669 a_n6543_n10895# a_n6543_n10895# VDD.t0 sg13_lv_pmos ad=0.19p pd=1.38u as=0.19p ps=1.38u w=1u l=0.7u
X1132 VDD.t96 a_n10106_3341# Von.t66 VDD.t1 sg13_lv_pmos ad=0.2603p pd=1.75u as=0.2603p ps=1.75u w=1.37u l=0.35u
X1133 Vop.t4 a_n10179_n275# VSS.t68 VSS.t9 sg13_lv_nmos ad=0.912p pd=5.18u as=0.912p ps=5.18u w=4.8u l=1.06u
X1134 a_n5006_n3441# a_n6543_n10895# VDD.t713 VDD.t0 sg13_lv_pmos ad=0.19p pd=1.38u as=0.19p ps=1.38u w=1u l=0.7u
X1135 a_286_1773# VNin.t0 a_n3162_51# VSS.t144 sg13_lv_nmos ad=0.209p pd=1.48u as=0.209p ps=1.48u w=1.1u l=0.15u
X1136 VDD.t434 a_1220_1772# Vop.t103 VDD.t1 sg13_lv_pmos ad=0.2603p pd=1.75u as=0.2603p ps=1.75u w=1.37u l=0.35u
X1137 VDD.t775 a_n6543_n10895# a_n5006_n3441# VDD.t0 sg13_lv_pmos ad=0.19p pd=1.38u as=0.19p ps=1.38u w=1u l=0.7u
X1138 VDD.t402 a_1220_1772# Vop.t111 VDD.t1 sg13_lv_pmos ad=0.2603p pd=1.75u as=0.2603p ps=1.75u w=1.37u l=0.35u
X1139 Vop.t71 a_1220_1772# VDD.t508 VDD.t1 sg13_lv_pmos ad=0.2603p pd=1.75u as=0.2603p ps=1.75u w=1.37u l=0.35u
X1140 VDD.t370 a_1220_1772# Vop.t96 VDD.t1 sg13_lv_pmos ad=0.2603p pd=1.75u as=0.2603p ps=1.75u w=1.37u l=0.35u
X1141 VDD.t490 a_1220_1772# Vop.t62 VDD.t1 sg13_lv_pmos ad=0.2603p pd=1.75u as=0.2603p ps=1.75u w=1.37u l=0.35u
X1142 a_n20570_n9414# VOUTN.t26 a_n14528_n9920# VSS.t261 sg13_lv_nmos ad=1.9p pd=10.38u as=1.9p ps=10.38u w=10u l=0.5u
X1143 Vop.t152 a_1220_1772# VDD.t584 VDD.t1 sg13_lv_pmos ad=0.2603p pd=1.75u as=0.2603p ps=1.75u w=1.37u l=0.35u
X1144 VDD.t216 a_n10106_3341# Von.t103 VDD.t1 sg13_lv_pmos ad=0.2603p pd=1.75u as=0.2603p ps=1.75u w=1.37u l=0.35u
X1145 a_n2002_n4396# a_n6543_n10895# VDD.t792 VDD.t0 sg13_lv_pmos ad=0.19p pd=1.38u as=0.19p ps=1.38u w=1u l=0.7u
X1146 Vop.t119 a_1220_1772# VDD.t417 VDD.t1 sg13_lv_pmos ad=0.2603p pd=1.75u as=0.4658p ps=3.42u w=1.37u l=0.35u
X1147 VDD.t188 a_n10106_3341# Von.t84 VDD.t1 sg13_lv_pmos ad=0.2603p pd=1.75u as=0.2603p ps=1.75u w=1.37u l=0.35u
X1148 Vop.t0 a_n10179_n275# VSS.t85 VSS.t9 sg13_lv_nmos ad=0.912p pd=5.18u as=0.912p ps=5.18u w=4.8u l=1.06u
X1149 a_1220_1772# a_n9221_n275# a_881_4136# VDD.t1 sg13_lv_pmos ad=0.7695p pd=4.43u as=1.377p ps=8.78u w=4.05u l=0.5u
X1150 a_n2002_n4396# a_n6543_n10895# VDD.t929 VDD.t0 sg13_lv_pmos ad=0.19p pd=1.38u as=0.19p ps=1.38u w=1u l=0.7u
X1151 VDD.t635 a_11820_n9920# a_13228_n9920# VDD.t633 sg13_lv_pmos ad=1.9p pd=10.38u as=1.9p ps=10.38u w=10u l=1u
X1152 a_13228_n9920# VOUTP.t26 a_11652_n9920# VSS.t0 sg13_lv_nmos ad=1.9p pd=10.38u as=1.9p ps=10.38u w=10u l=0.5u
X1153 VDD.t723 a_n6543_n10895# a_n5006_n3441# VDD.t0 sg13_lv_pmos ad=0.19p pd=1.38u as=0.19p ps=1.38u w=1u l=0.7u
X1154 VDD.t348 a_1220_1772# Vop.t47 VDD.t1 sg13_lv_pmos ad=0.2603p pd=1.75u as=0.2603p ps=1.75u w=1.37u l=0.35u
X1155 CMFBout.t12 Vop.t158 a_n2002_n4396# VDD.t0 sg13_lv_pmos ad=0.24415p pd=1.665u as=0.24415p ps=1.665u w=1.285u l=0.35u
X1156 a_n3381_1772# a_n9221_n275# a_n10106_3341# VDD.t1 sg13_lv_pmos ad=1.377p pd=8.78u as=0.7695p ps=4.43u w=4.05u l=0.5u
X1157 a_n9221_n275# a_n10179_n275# VSS.t122 VSS.t121 sg13_lv_nmos ad=1.632p pd=10.28u as=0.912p ps=5.18u w=4.8u l=1.06u
X1158 a_n3162_51# VPin.t0 a_n1828_1772# VSS.t152 sg13_lv_nmos ad=0.209p pd=1.48u as=0.209p ps=1.48u w=1.1u l=0.15u
X1159 VDD.t426 a_1220_1772# Vop.t98 VDD.t1 sg13_lv_pmos ad=0.4658p pd=3.42u as=0.2603p ps=1.75u w=1.37u l=0.35u
X1160 CMFBout.t33 CMFBout.t30 VSS.t286 VSS.t287 sg13_lv_nmos ad=0.6327p pd=3.71u as=0.6327p ps=3.71u w=3.33u l=0.2u
X1161 Vop.t22 a_n10179_n275# VSS.t82 VSS.t9 sg13_lv_nmos ad=1.632p pd=10.28u as=0.912p ps=5.18u w=4.8u l=1.06u
X1162 VPout.t0 VP.t0 VSS.t265 rppd l=6.73u w=0.6u
X1163 VSS.t225 CMFBin.t10 a_n3162_51# VSS.t224 sg13_lv_nmos ad=0.6327p pd=3.71u as=0.6327p ps=3.71u w=3.33u l=0.2u
X1164 VDD.t853 a_n6543_n10895# a_n5006_n3441# VDD.t0 sg13_lv_pmos ad=0.19p pd=1.38u as=0.19p ps=1.38u w=1u l=0.7u
X1165 VDD.t350 a_1220_1772# Vop.t48 VDD.t1 sg13_lv_pmos ad=0.2603p pd=1.75u as=0.2603p ps=1.75u w=1.37u l=0.35u
X1166 a_881_4136# a_n10013_2465# VDD.t65 VDD.t1 sg13_lv_pmos ad=1.33p pd=7.38u as=1.33p ps=7.38u w=7u l=0.7u
X1167 a_n1828_1772# a_n8929_2739# a_n10106_3341# VSS.t323 sg13_lv_nmos ad=0.361p pd=2.28u as=0.361p ps=2.28u w=1.9u l=0.16u
X1168 VDD.t472 a_1220_1772# Vop.t73 VDD.t1 sg13_lv_pmos ad=0.2603p pd=1.75u as=0.2603p ps=1.75u w=1.37u l=0.35u
X1169 VDD.t440 a_1220_1772# Vop.t144 VDD.t1 sg13_lv_pmos ad=0.2603p pd=1.75u as=0.2603p ps=1.75u w=1.37u l=0.35u
X1170 VDD.t946 a_n6543_n10895# a_n5006_n3441# VDD.t0 sg13_lv_pmos ad=0.19p pd=1.38u as=0.19p ps=1.38u w=1u l=0.7u
X1171 Von.t47 a_n10106_3341# VDD.t280 VDD.t1 sg13_lv_pmos ad=0.2603p pd=1.75u as=0.2603p ps=1.75u w=1.37u l=0.35u
X1172 a_n2002_n4396# a_n6543_n10895# VDD.t743 VDD.t0 sg13_lv_pmos ad=0.19p pd=1.38u as=0.19p ps=1.38u w=1u l=0.7u
X1173 a_n1828_1772# a_n8929_2739# a_n10106_3341# VSS.t327 sg13_lv_nmos ad=0.646p pd=4.48u as=0.361p ps=2.28u w=1.9u l=0.16u
X1174 a_881_4136# a_n10013_2465# VDD.t40 VDD.t1 sg13_lv_pmos ad=1.33p pd=7.38u as=2.38p ps=14.68u w=7u l=0.7u
X1175 Von.t74 a_n10106_3341# VDD.t236 VDD.t1 sg13_lv_pmos ad=0.2603p pd=1.75u as=0.2603p ps=1.75u w=1.37u l=0.35u
X1176 VSS.t39 a_n10179_n275# Von.t18 VSS.t11 sg13_lv_nmos ad=0.912p pd=5.18u as=1.632p ps=10.28u w=4.8u l=1.06u
X1177 a_n3162_51# CMFBin.t2 VSS.t249 VSS.t250 sg13_lv_nmos ad=0.6327p pd=3.71u as=0.6327p ps=3.71u w=3.33u l=0.2u
X1178 Von.t105 a_n10106_3341# VDD.t208 VDD.t1 sg13_lv_pmos ad=0.2603p pd=1.75u as=0.2603p ps=1.75u w=1.37u l=0.35u
X1179 a_n5006_n3441# Von.t158 CMFBout.t29 VDD.t0 sg13_lv_pmos ad=0.24415p pd=1.665u as=0.24415p ps=1.665u w=1.285u l=0.35u
X1180 a_n1828_1772# VPin.t0 a_n3162_51# VSS.t153 sg13_lv_nmos ad=0.209p pd=1.48u as=0.209p ps=1.48u w=1.1u l=0.15u
X1181 VDD.t877 a_n6543_n10895# a_n2002_n4396# VDD.t0 sg13_lv_pmos ad=0.19p pd=1.38u as=0.19p ps=1.38u w=1u l=0.7u
X1182 VDD.t620 a_13228_n9920# VOUTP.t7 VSS.t174 sg13_lv_nmos ad=3.4p pd=20.68u as=3.4p ps=20.68u w=10u l=0.15u
X1183 a_n5006_n3441# Von.t158 CMFBout.t26 VDD.t0 sg13_lv_pmos ad=0.24415p pd=1.665u as=0.24415p ps=1.665u w=1.285u l=0.35u
X1184 Vop.t112 a_1220_1772# VDD.t402 VDD.t1 sg13_lv_pmos ad=0.2603p pd=1.75u as=0.2603p ps=1.75u w=1.37u l=0.35u
X1185 a_n1828_1772# a_n8929_2739# a_n10106_3341# VSS.t323 sg13_lv_nmos ad=0.361p pd=2.28u as=0.361p ps=2.28u w=1.9u l=0.16u
X1186 a_n6543_n10895# a_n6543_n10895# VDD.t677 VDD.t0 sg13_lv_pmos ad=0.19p pd=1.38u as=0.19p ps=1.38u w=1u l=0.7u
X1187 VSS.t77 a_n10179_n275# Vop.t12 VSS.t9 sg13_lv_nmos ad=0.912p pd=5.18u as=0.912p ps=5.18u w=4.8u l=1.06u
X1188 VDD.t314 a_n10106_3341# Von.t135 VDD.t1 sg13_lv_pmos ad=0.4658p pd=3.42u as=0.2603p ps=1.75u w=1.37u l=0.35u
X1189 VDD.t418 a_1220_1772# Vop.t119 VDD.t1 sg13_lv_pmos ad=0.2603p pd=1.75u as=0.2603p ps=1.75u w=1.37u l=0.35u
X1190 a_n3162_51# CMFBin.t20 VSS.t195 VSS.t196 sg13_lv_nmos ad=0.6327p pd=3.71u as=0.6327p ps=3.71u w=3.33u l=0.2u
X1191 a_1220_1772# a_n9221_n275# a_881_4136# VDD.t1 sg13_lv_pmos ad=0.7695p pd=4.43u as=1.377p ps=8.78u w=4.05u l=0.5u
X1192 Von.t13 a_n10179_n275# VSS.t15 VSS.t16 sg13_lv_nmos ad=0.912p pd=5.18u as=0.912p ps=5.18u w=4.8u l=1.06u
X1193 CMFBout.t32 CMFBout.t30 VSS.t292 VSS.t293 sg13_lv_nmos ad=0.6327p pd=3.71u as=0.6327p ps=3.71u w=3.33u l=0.2u
X1194 VOUTN.t11 a_n20570_n9414# VDD.t93 VSS.t139 sg13_lv_nmos ad=3.4p pd=20.68u as=3.4p ps=20.68u w=10u l=0.15u
X1195 VDD.t230 a_n10106_3341# Von.t72 VDD.t1 sg13_lv_pmos ad=0.2603p pd=1.75u as=0.2603p ps=1.75u w=1.37u l=0.35u
X1196 VDD.t202 a_n10106_3341# Von.t89 VDD.t1 sg13_lv_pmos ad=0.2603p pd=1.75u as=0.2603p ps=1.75u w=1.37u l=0.35u
X1197 a_n14155_n5285# Von.t157 a_n14528_n9920# VSS.t303 sg13_lv_nmos ad=1.9p pd=10.38u as=1.9p ps=10.38u w=10u l=0.5u
X1198 a_n3381_1772# a_n9221_n275# a_n10106_3341# VDD.t1 sg13_lv_pmos ad=1.377p pd=8.78u as=0.7695p ps=4.43u w=4.05u l=0.5u
X1199 a_n5006_n3441# VREF.t0 a_36_n4396# VDD.t0 sg13_lv_pmos ad=0.24415p pd=1.665u as=0.24415p ps=1.665u w=1.285u l=0.35u
X1200 Von.t95 a_n10106_3341# VDD.t126 VDD.t1 sg13_lv_pmos ad=0.2603p pd=1.75u as=0.2603p ps=1.75u w=1.37u l=0.35u
X1201 a_n3162_51# VNin.t0 a_286_1773# VSS.t143 sg13_lv_nmos ad=0.209p pd=1.48u as=0.209p ps=1.48u w=1.1u l=0.15u
X1202 a_n2002_n4396# VREF.t0 a_36_n4396# VDD.t0 sg13_lv_pmos ad=0.24415p pd=1.665u as=0.24415p ps=1.665u w=1.285u l=0.35u
X1203 a_n5006_n3441# VREF.t0 a_36_n4396# VDD.t0 sg13_lv_pmos ad=0.24415p pd=1.665u as=0.24415p ps=1.665u w=1.285u l=0.35u
X1204 a_n5006_n3441# a_n6543_n10895# VDD.t811 VDD.t0 sg13_lv_pmos ad=0.19p pd=1.38u as=0.19p ps=1.38u w=1u l=0.7u
X1205 Von.t22 a_n10179_n275# VSS.t45 VSS.t22 sg13_lv_nmos ad=0.912p pd=5.18u as=0.912p ps=5.18u w=4.8u l=1.06u
X1206 Von.t84 a_n10106_3341# VDD.t186 VDD.t1 sg13_lv_pmos ad=0.2603p pd=1.75u as=0.2603p ps=1.75u w=1.37u l=0.35u
X1207 a_881_4136# a_n10013_2465# VDD.t49 VDD.t1 sg13_lv_pmos ad=1.33p pd=7.38u as=1.33p ps=7.38u w=7u l=0.7u
X1208 a_n3341_6527# Von.t155 cap_cmim l=21.4u w=21.4u
X1209 a_n1828_1772# VPin.t0 a_n3162_51# VSS.t153 sg13_lv_nmos ad=0.209p pd=1.48u as=0.209p ps=1.48u w=1.1u l=0.15u
X1210 a_n3162_51# VPin.t0 a_n1828_1772# VSS.t152 sg13_lv_nmos ad=0.209p pd=1.48u as=0.209p ps=1.48u w=1.1u l=0.15u
X1211 Vop.t57 a_1220_1772# VDD.t472 VDD.t1 sg13_lv_pmos ad=0.2603p pd=1.75u as=0.2603p ps=1.75u w=1.37u l=0.35u
X1212 VSS.t124 a_n10179_n275# Vop.t7 VSS.t9 sg13_lv_nmos ad=0.912p pd=5.18u as=0.912p ps=5.18u w=4.8u l=1.06u
X1213 a_286_1773# VNin.t0 a_n3162_51# VSS.t142 sg13_lv_nmos ad=0.209p pd=1.48u as=0.374p ps=2.88u w=1.1u l=0.15u
X1214 VDD.t17 a_n10013_2465# a_n3381_1772# VDD.t1 sg13_lv_pmos ad=1.33p pd=7.38u as=1.33p ps=7.38u w=7u l=0.7u
X1215 VDD.t236 a_n10106_3341# Von.t41 VDD.t1 sg13_lv_pmos ad=0.2603p pd=1.75u as=0.2603p ps=1.75u w=1.37u l=0.35u
X1216 VSS.t273 a_n13845_n10915# a_n14528_n9920# VSS.t272 sg13_lv_nmos ad=1.02p pd=6.68u as=0.57p ps=3.38u w=3u l=1u
X1217 Vop.t116 a_1220_1772# VDD.t377 VDD.t1 sg13_lv_pmos ad=0.2603p pd=1.75u as=0.4658p ps=3.42u w=1.37u l=0.35u
X1218 VDD.t208 a_n10106_3341# Von.t104 VDD.t1 sg13_lv_pmos ad=0.2603p pd=1.75u as=0.2603p ps=1.75u w=1.37u l=0.35u
X1219 a_n10106_3341# a_n8929_2739# a_n1828_1772# VSS.t324 sg13_lv_nmos ad=0.361p pd=2.28u as=0.361p ps=2.28u w=1.9u l=0.16u
X1220 VDD.t898 a_n6543_n10895# a_n5006_n3441# VDD.t0 sg13_lv_pmos ad=0.19p pd=1.38u as=0.19p ps=1.38u w=1u l=0.7u
X1221 VDD.t634 a_11820_n9920# a_11820_n9920# VDD.t633 sg13_lv_pmos ad=1.9p pd=10.38u as=1.9p ps=10.38u w=10u l=1u
X1222 a_n5006_n3441# a_n6543_n10895# VDD.t848 VDD.t0 sg13_lv_pmos ad=0.19p pd=1.38u as=0.19p ps=1.38u w=1u l=0.7u
X1223 VDD.t844 a_n6543_n10895# a_n2002_n4396# VDD.t0 sg13_lv_pmos ad=0.19p pd=1.38u as=0.19p ps=1.38u w=1u l=0.7u
X1224 Vop.t137 a_1220_1772# VDD.t540 VDD.t1 sg13_lv_pmos ad=0.2603p pd=1.75u as=0.2603p ps=1.75u w=1.37u l=0.35u
X1225 a_n5006_n3441# a_n6543_n10895# VDD.t861 VDD.t0 sg13_lv_pmos ad=0.19p pd=1.38u as=0.19p ps=1.38u w=1u l=0.7u
X1226 a_286_1773# a_n8929_2739# a_1220_1772# VSS.t329 sg13_lv_nmos ad=0.361p pd=2.28u as=0.361p ps=2.28u w=1.9u l=0.16u
X1227 a_36_n4396# VREF.t0 a_n2002_n4396# VDD.t0 sg13_lv_pmos ad=0.24415p pd=1.665u as=0.24415p ps=1.665u w=1.285u l=0.35u
X1228 VDD.t272 a_n10106_3341# Von.t34 VDD.t1 sg13_lv_pmos ad=0.2603p pd=1.75u as=0.2603p ps=1.75u w=1.37u l=0.35u
X1229 a_n5006_n3441# a_n6543_n10895# VDD.t954 VDD.t0 sg13_lv_pmos ad=0.19p pd=1.38u as=0.19p ps=1.38u w=1u l=0.7u
X1230 a_n5006_n3441# a_n6543_n10895# VDD.t765 VDD.t0 sg13_lv_pmos ad=0.19p pd=1.38u as=0.19p ps=1.38u w=1u l=0.7u
X1231 a_n14155_n5285# Von.t157 a_n14528_n9920# VSS.t299 sg13_lv_nmos ad=1.9p pd=10.38u as=1.9p ps=10.38u w=10u l=0.5u
X1232 a_n20570_n9414# VOUTN.t26 a_n14528_n9920# VSS.t257 sg13_lv_nmos ad=1.9p pd=10.38u as=3.4p ps=20.68u w=10u l=0.5u
X1233 a_1220_1772# a_n9221_n275# a_881_4136# VDD.t1 sg13_lv_pmos ad=0.7695p pd=4.43u as=0.7695p ps=4.43u w=4.05u l=0.5u
X1234 a_881_4136# a_n9221_n275# a_1220_1772# VDD.t1 sg13_lv_pmos ad=1.377p pd=8.78u as=0.7695p ps=4.43u w=4.05u l=0.5u
X1235 a_n10106_3341# a_n8929_2739# a_n1828_1772# VSS.t324 sg13_lv_nmos ad=0.361p pd=2.28u as=0.361p ps=2.28u w=1.9u l=0.16u
X1236 VDD.t404 a_1220_1772# Vop.t112 VDD.t1 sg13_lv_pmos ad=0.2603p pd=1.75u as=0.2603p ps=1.75u w=1.37u l=0.35u
X1237 CMFBout.t1 Vop.t158 a_n2002_n4396# VDD.t0 sg13_lv_pmos ad=0.24415p pd=1.665u as=0.24415p ps=1.665u w=1.285u l=0.35u
X1238 Vop.t55 a_1220_1772# VDD.t510 VDD.t1 sg13_lv_pmos ad=0.2603p pd=1.75u as=0.2603p ps=1.75u w=1.37u l=0.35u
X1239 a_n3162_51# CMFBin.t8 VSS.t231 VSS.t232 sg13_lv_nmos ad=0.6327p pd=3.71u as=0.6327p ps=3.71u w=3.33u l=0.2u
X1240 a_n6543_n10895# a_n6543_n10895# VDD.t665 VDD.t0 sg13_lv_pmos ad=0.19p pd=1.38u as=0.19p ps=1.38u w=1u l=0.7u
X1241 a_n3381_1772# a_n9221_n275# a_n10106_3341# VDD.t1 sg13_lv_pmos ad=0.7695p pd=4.43u as=0.7695p ps=4.43u w=4.05u l=0.5u
X1242 VDD.t492 a_1220_1772# Vop.t63 VDD.t1 sg13_lv_pmos ad=0.2603p pd=1.75u as=0.2603p ps=1.75u w=1.37u l=0.35u
X1243 VSS.t34 a_n10179_n275# Von.t21 VSS.t20 sg13_lv_nmos ad=0.912p pd=5.18u as=0.912p ps=5.18u w=4.8u l=1.06u
X1244 a_n10106_3341# a_n9221_n275# a_n3381_1772# VDD.t1 sg13_lv_pmos ad=0.7695p pd=4.43u as=1.377p ps=8.78u w=4.05u l=0.5u
X1245 a_1220_1772# a_n8929_2739# a_286_1773# VSS.t332 sg13_lv_nmos ad=0.361p pd=2.28u as=0.361p ps=2.28u w=1.9u l=0.16u
X1246 VDD.t711 a_n6543_n10895# a_n5006_n3441# VDD.t0 sg13_lv_pmos ad=0.19p pd=1.38u as=0.19p ps=1.38u w=1u l=0.7u
X1247 VDD.t460 a_1220_1772# Vop.t75 VDD.t1 sg13_lv_pmos ad=0.2603p pd=1.75u as=0.2603p ps=1.75u w=1.37u l=0.35u
X1248 VDD.t366 a_1220_1772# Vop.t44 VDD.t1 sg13_lv_pmos ad=0.4658p pd=3.42u as=0.2603p ps=1.75u w=1.37u l=0.35u
X1249 VDD.t30 a_n10013_2465# a_n10013_2465# VDD.t1 sg13_lv_pmos ad=0.476p pd=3.48u as=0.266p ps=1.78u w=1.4u l=0.35u
X1250 VDD.t132 a_n10106_3341# Von.t53 VDD.t1 sg13_lv_pmos ad=0.2603p pd=1.75u as=0.2603p ps=1.75u w=1.37u l=0.35u
X1251 VDD.t883 a_n6543_n10895# a_n2002_n4396# VDD.t0 sg13_lv_pmos ad=0.19p pd=1.38u as=0.19p ps=1.38u w=1u l=0.7u
X1252 Von.t131 a_n10106_3341# VDD.t300 VDD.t1 sg13_lv_pmos ad=0.2603p pd=1.75u as=0.2603p ps=1.75u w=1.37u l=0.35u
X1253 VDD.t186 a_n10106_3341# Von.t83 VDD.t1 sg13_lv_pmos ad=0.2603p pd=1.75u as=0.2603p ps=1.75u w=1.37u l=0.35u
X1254 Vop.t110 a_1220_1772# VDD.t387 VDD.t1 sg13_lv_pmos ad=0.2603p pd=1.75u as=0.4658p ps=3.42u w=1.37u l=0.35u
X1255 Von.t72 a_n10106_3341# VDD.t228 VDD.t1 sg13_lv_pmos ad=0.2603p pd=1.75u as=0.2603p ps=1.75u w=1.37u l=0.35u
X1256 a_n2373_n10895# a_n6543_n9623# a_n3721_n10895# VSS.t315 sg13_lv_nmos ad=1.14p pd=6.38u as=1.14p ps=6.38u w=6u l=6.4u
X1257 a_n2002_n4396# a_n6543_n10895# VDD.t871 VDD.t0 sg13_lv_pmos ad=0.19p pd=1.38u as=0.19p ps=1.38u w=1u l=0.7u
X1258 VDD.t796 a_n6543_n10895# a_n2002_n4396# VDD.t0 sg13_lv_pmos ad=0.19p pd=1.38u as=0.19p ps=1.38u w=1u l=0.7u
X1259 a_n3381_1772# a_n10013_2465# VDD.t23 VDD.t1 sg13_lv_pmos ad=1.33p pd=7.38u as=1.33p ps=7.38u w=7u l=0.7u
X1260 VDD.t782 a_n6543_n10895# a_n2002_n4396# VDD.t0 sg13_lv_pmos ad=0.19p pd=1.38u as=0.19p ps=1.38u w=1u l=0.7u
X1261 Vop.t11 a_n10179_n275# VSS.t93 VSS.t9 sg13_lv_nmos ad=1.632p pd=10.28u as=0.912p ps=5.18u w=4.8u l=1.06u
X1262 VDD.t396 a_1220_1772# Vop.t122 VDD.t1 sg13_lv_pmos ad=0.4658p pd=3.42u as=0.2603p ps=1.75u w=1.37u l=0.35u
X1263 VDD.t334 a_n10106_3341# Von.t136 VDD.t1 sg13_lv_pmos ad=0.4658p pd=3.42u as=0.2603p ps=1.75u w=1.37u l=0.35u
X1264 a_n3721_n10895# a_n3721_n10895# a_n6543_n9623# VSS.t266 sg13_lv_nmos ad=0.68p pd=4.68u as=0.68p ps=4.68u w=2u l=1u
X1265 VOUTN.t6 a_n20570_n9414# VDD.t74 VSS.t137 sg13_lv_nmos ad=3.4p pd=20.68u as=3.4p ps=20.68u w=10u l=0.15u
X1266 a_n2002_n4396# Vop.t158 CMFBout.t4 VDD.t0 sg13_lv_pmos ad=0.24415p pd=1.665u as=0.24415p ps=1.665u w=1.285u l=0.35u
X1267 a_286_1773# VNin.t0 a_n3162_51# VSS.t142 sg13_lv_nmos ad=0.209p pd=1.48u as=0.374p ps=2.88u w=1.1u l=0.15u
X1268 VSS.t100 a_n10179_n275# Von.t8 VSS.t17 sg13_lv_nmos ad=0.912p pd=5.18u as=0.912p ps=5.18u w=4.8u l=1.06u
X1269 VDD.t474 a_1220_1772# Vop.t57 VDD.t1 sg13_lv_pmos ad=0.2603p pd=1.75u as=0.2603p ps=1.75u w=1.37u l=0.35u
X1270 a_n3162_51# CMFBin.t19 VSS.t198 VSS.t199 sg13_lv_nmos ad=0.6327p pd=3.71u as=0.6327p ps=3.71u w=3.33u l=0.2u
X1271 VDD.t442 a_1220_1772# Vop.t145 VDD.t1 sg13_lv_pmos ad=0.2603p pd=1.75u as=0.2603p ps=1.75u w=1.37u l=0.35u
X1272 a_n1828_1772# a_n8929_2739# a_n10106_3341# VSS.t325 sg13_lv_nmos ad=0.361p pd=2.28u as=0.361p ps=2.28u w=1.9u l=0.16u
X1273 a_881_4136# a_n10013_2465# VDD.t46 VDD.t1 sg13_lv_pmos ad=1.33p pd=7.38u as=2.38p ps=14.68u w=7u l=0.7u
X1274 VSS.t70 a_n10179_n275# Vop.t4 VSS.t9 sg13_lv_nmos ad=0.912p pd=5.18u as=0.912p ps=5.18u w=4.8u l=1.06u
X1275 Von.t67 a_n10106_3341# VDD.t165 VDD.t1 sg13_lv_pmos ad=0.2603p pd=1.75u as=0.4658p ps=3.42u w=1.37u l=0.35u
X1276 Von.t99 a_n10106_3341# VDD.t250 VDD.t1 sg13_lv_pmos ad=0.2603p pd=1.75u as=0.2603p ps=1.75u w=1.37u l=0.35u
X1277 a_36_n4396# VREF.t0 a_n5006_n3441# VDD.t0 sg13_lv_pmos ad=0.24415p pd=1.665u as=0.24415p ps=1.665u w=1.285u l=0.35u
X1278 VDD.t77 a_n20570_n9414# VOUTN.t10 VSS.t140 sg13_lv_nmos ad=3.4p pd=20.68u as=3.4p ps=20.68u w=10u l=0.15u
X1279 a_1220_1772# a_n8929_2739# a_286_1773# VSS.t328 sg13_lv_nmos ad=0.361p pd=2.28u as=0.646p ps=4.48u w=1.9u l=0.16u
X1280 Von.t104 a_n10106_3341# VDD.t206 VDD.t1 sg13_lv_pmos ad=0.2603p pd=1.75u as=0.2603p ps=1.75u w=1.37u l=0.35u
X1281 VOUTN.t13 a_n20570_n9414# VDD.t89 VSS.t135 sg13_lv_nmos ad=3.4p pd=20.68u as=3.4p ps=20.68u w=10u l=0.15u
X1282 a_n5006_n3441# a_n6543_n10895# VDD.t906 VDD.t0 sg13_lv_pmos ad=0.19p pd=1.38u as=0.19p ps=1.38u w=1u l=0.7u
X1283 Von.t101 a_n10106_3341# VDD.t162 VDD.t1 sg13_lv_pmos ad=0.2603p pd=1.75u as=0.2603p ps=1.75u w=1.37u l=0.35u
X1284 a_n2002_n4396# Vop.t158 CMFBout.t3 VDD.t0 sg13_lv_pmos ad=0.24415p pd=1.665u as=0.24415p ps=1.665u w=1.285u l=0.35u
X1285 VDD.t646 a_n14155_n5285# a_n20570_n9414# VDD.t642 sg13_lv_pmos ad=1.9p pd=10.38u as=1.9p ps=10.38u w=10u l=1u
X1286 Vop.t54 a_1220_1772# VDD.t492 VDD.t1 sg13_lv_pmos ad=0.2603p pd=1.75u as=0.2603p ps=1.75u w=1.37u l=0.35u
X1287 a_n2002_n4396# a_n6543_n10895# VDD.t879 VDD.t0 sg13_lv_pmos ad=0.19p pd=1.38u as=0.19p ps=1.38u w=1u l=0.7u
X1288 VSS.t87 a_n10179_n275# Vop.t0 VSS.t9 sg13_lv_nmos ad=0.912p pd=5.18u as=0.912p ps=5.18u w=4.8u l=1.06u
X1289 Vop.t14 a_n10179_n275# VSS.t62 VSS.t61 sg13_lv_nmos ad=0.912p pd=5.18u as=1.632p ps=10.28u w=4.8u l=1.06u
X1290 Vop.t98 a_1220_1772# VDD.t424 VDD.t1 sg13_lv_pmos ad=0.2603p pd=1.75u as=0.2603p ps=1.75u w=1.37u l=0.35u
X1291 a_11820_n9920# Vop.t157 a_11652_n9920# VSS.t163 sg13_lv_nmos ad=1.9p pd=10.38u as=1.9p ps=10.38u w=10u l=0.5u
X1292 Von.t32 a_n10106_3341# VDD.t122 VDD.t1 sg13_lv_pmos ad=0.2603p pd=1.75u as=0.2603p ps=1.75u w=1.37u l=0.35u
X1293 a_n20570_n9414# VOUTN.t26 a_n14528_n9920# VSS.t263 sg13_lv_nmos ad=1.9p pd=10.38u as=1.9p ps=10.38u w=10u l=0.5u
X1294 a_n1828_1772# a_n8929_2739# a_n10106_3341# VSS.t325 sg13_lv_nmos ad=0.361p pd=2.28u as=0.361p ps=2.28u w=1.9u l=0.16u
X1295 VDD.t388 a_1220_1772# Vop.t110 VDD.t1 sg13_lv_pmos ad=0.2603p pd=1.75u as=0.2603p ps=1.75u w=1.37u l=0.35u
X1296 VDD.t92 a_n20570_n9414# VOUTN.t4 VSS.t138 sg13_lv_nmos ad=3.4p pd=20.68u as=3.4p ps=20.68u w=10u l=0.15u
X1297 VDD.t228 a_n10106_3341# Von.t71 VDD.t1 sg13_lv_pmos ad=0.2603p pd=1.75u as=0.2603p ps=1.75u w=1.37u l=0.35u
X1298 VDD.t200 a_n10106_3341# Von.t88 VDD.t1 sg13_lv_pmos ad=0.2603p pd=1.75u as=0.2603p ps=1.75u w=1.37u l=0.35u
X1299 a_286_1773# a_n8929_2739# a_1220_1772# VSS.t331 sg13_lv_nmos ad=0.361p pd=2.28u as=0.361p ps=2.28u w=1.9u l=0.16u
X1300 VSS.t122 a_n10179_n275# a_n10013_2465# VSS.t132 sg13_lv_nmos ad=0.912p pd=5.18u as=1.632p ps=10.28u w=4.8u l=1.06u
X1301 VDD.t661 a_n6543_n10895# a_n6543_n10895# VDD.t0 sg13_lv_pmos ad=0.19p pd=1.38u as=0.19p ps=1.38u w=1u l=0.7u
X1302 Vop.t85 a_1220_1772# VDD.t528 VDD.t1 sg13_lv_pmos ad=0.2603p pd=1.75u as=0.2603p ps=1.75u w=1.37u l=0.35u
X1303 a_n10013_2465# a_n10013_2465# VDD.t28 VDD.t1 sg13_lv_pmos ad=0.266p pd=1.78u as=0.266p ps=1.78u w=1.4u l=0.35u
X1304 a_n5006_n3441# a_n6543_n10895# VDD.t719 VDD.t0 sg13_lv_pmos ad=0.19p pd=1.38u as=0.19p ps=1.38u w=1u l=0.7u
X1305 Von.t129 a_n10106_3341# VDD.t320 VDD.t1 sg13_lv_pmos ad=0.2603p pd=1.75u as=0.2603p ps=1.75u w=1.37u l=0.35u
X1306 a_n3721_n10895# a_n3721_n10895# VDD.t624 VDD.t622 sg13_lv_pmos ad=1.14p pd=6.38u as=1.14p ps=6.38u w=6u l=2.5u
X1307 VDD.t608 a_13228_n9920# VOUTP.t10 VSS.t170 sg13_lv_nmos ad=3.4p pd=20.68u as=3.4p ps=20.68u w=10u l=0.15u
X1308 VDD.t110 a_n10106_3341# Von.t118 VDD.t1 sg13_lv_pmos ad=0.2603p pd=1.75u as=0.2603p ps=1.75u w=1.37u l=0.35u
X1309 CMFBout.t19 Von.t158 a_n5006_n3441# VDD.t0 sg13_lv_pmos ad=0.24415p pd=1.665u as=0.24415p ps=1.665u w=1.285u l=0.35u
X1310 CMFBout.t7 Vop.t158 a_n2002_n4396# VDD.t0 sg13_lv_pmos ad=0.4369p pd=3.25u as=0.24415p ps=1.665u w=1.285u l=0.35u
X1311 VDD.t809 a_n6543_n10895# a_n5006_n3441# VDD.t0 sg13_lv_pmos ad=0.19p pd=1.38u as=0.19p ps=1.38u w=1u l=0.7u
X1312 a_n2002_n4396# a_n6543_n10895# VDD.t786 VDD.t0 sg13_lv_pmos ad=0.19p pd=1.38u as=0.19p ps=1.38u w=1u l=0.7u
X1313 VSS.t222 CMFBin.t11 a_n3162_51# VSS.t221 sg13_lv_nmos ad=0.6327p pd=3.71u as=0.6327p ps=3.71u w=3.33u l=0.2u
X1314 Vop.t105 a_1220_1772# VDD.t442 VDD.t1 sg13_lv_pmos ad=0.2603p pd=1.75u as=0.2603p ps=1.75u w=1.37u l=0.35u
X1315 Von.t59 a_n10106_3341# VDD.t102 VDD.t1 sg13_lv_pmos ad=0.2603p pd=1.75u as=0.2603p ps=1.75u w=1.37u l=0.35u
X1316 VSS.t213 CMFBin.t14 a_n3162_51# VSS.t212 sg13_lv_nmos ad=0.6327p pd=3.71u as=0.6327p ps=3.71u w=3.33u l=0.2u
X1317 a_n5006_n3441# a_n6543_n10895# VDD.t655 VDD.t0 sg13_lv_pmos ad=0.19p pd=1.38u as=0.19p ps=1.38u w=1u l=0.7u
X1318 VDD.t480 a_1220_1772# Vop.t65 VDD.t1 sg13_lv_pmos ad=0.2603p pd=1.75u as=0.2603p ps=1.75u w=1.37u l=0.35u
X1319 VDD.t65 a_n10013_2465# a_881_4136# VDD.t1 sg13_lv_pmos ad=1.33p pd=7.38u as=1.33p ps=7.38u w=7u l=0.7u
X1320 VDD.t206 a_n10106_3341# Von.t91 VDD.t1 sg13_lv_pmos ad=0.2603p pd=1.75u as=0.2603p ps=1.75u w=1.37u l=0.35u
X1321 VDD.t833 a_n6543_n10895# a_n2002_n4396# VDD.t0 sg13_lv_pmos ad=0.19p pd=1.38u as=0.19p ps=1.38u w=1u l=0.7u
X1322 a_n5006_n3441# a_n6543_n10895# VDD.t754 VDD.t0 sg13_lv_pmos ad=0.19p pd=1.38u as=0.19p ps=1.38u w=1u l=0.7u
X1323 a_n10106_3341# a_n8929_2739# a_n1828_1772# VSS.t326 sg13_lv_nmos ad=0.361p pd=2.28u as=0.361p ps=2.28u w=1.9u l=0.16u
X1324 VDD.t270 a_n10106_3341# Von.t37 VDD.t1 sg13_lv_pmos ad=0.2603p pd=1.75u as=0.2603p ps=1.75u w=1.37u l=0.35u
X1325 Vop.t13 a_n10179_n275# VSS.t77 VSS.t9 sg13_lv_nmos ad=0.912p pd=5.18u as=0.912p ps=5.18u w=4.8u l=1.06u
X1326 Vop.t96 a_1220_1772# VDD.t368 VDD.t1 sg13_lv_pmos ad=0.2603p pd=1.75u as=0.2603p ps=1.75u w=1.37u l=0.35u
X1327 a_n2002_n4396# a_n6543_n10895# VDD.t964 VDD.t0 sg13_lv_pmos ad=0.19p pd=1.38u as=0.19p ps=1.38u w=1u l=0.7u
X1328 a_36_n4396# VREF.t0 a_n2002_n4396# VDD.t0 sg13_lv_pmos ad=0.24415p pd=1.665u as=0.24415p ps=1.665u w=1.285u l=0.35u
X1329 a_n14155_n5285# Von.t157 a_n14528_n9920# VSS.t305 sg13_lv_nmos ad=1.9p pd=10.38u as=1.9p ps=10.38u w=10u l=0.5u
X1330 a_n20570_n9414# a_n14155_n5285# VDD.t643 VDD.t642 sg13_lv_pmos ad=1.9p pd=10.38u as=3.4p ps=20.68u w=10u l=1u
X1331 a_n5006_n3441# a_n6543_n10895# VDD.t865 VDD.t0 sg13_lv_pmos ad=0.19p pd=1.38u as=0.19p ps=1.38u w=1u l=0.7u
X1332 VDD.t952 a_n6543_n10895# a_n5006_n3441# VDD.t0 sg13_lv_pmos ad=0.19p pd=1.38u as=0.19p ps=1.38u w=1u l=0.7u
X1333 a_n10106_3341# a_n8929_2739# a_n1828_1772# VSS.t326 sg13_lv_nmos ad=0.361p pd=2.28u as=0.361p ps=2.28u w=1.9u l=0.16u
X1334 VDD.t494 a_1220_1772# Vop.t54 VDD.t1 sg13_lv_pmos ad=0.2603p pd=1.75u as=0.2603p ps=1.75u w=1.37u l=0.35u
X1335 VSS.t45 a_n10179_n275# Von.t11 VSS.t20 sg13_lv_nmos ad=0.912p pd=5.18u as=0.912p ps=5.18u w=4.8u l=1.06u
X1336 a_11820_n9920# Vop.t157 a_11652_n9920# VSS.t165 sg13_lv_nmos ad=1.9p pd=10.38u as=3.4p ps=20.68u w=10u l=0.5u
X1337 VDD.t462 a_1220_1772# Vop.t76 VDD.t1 sg13_lv_pmos ad=0.2603p pd=1.75u as=0.2603p ps=1.75u w=1.37u l=0.35u
X1338 VDD.t28 a_n10013_2465# a_n10013_2465# VDD.t1 sg13_lv_pmos ad=0.266p pd=1.78u as=0.266p ps=1.78u w=1.4u l=0.35u
X1339 a_1220_1772# a_n8929_2739# a_286_1773# VSS.t330 sg13_lv_nmos ad=0.361p pd=2.28u as=0.361p ps=2.28u w=1.9u l=0.16u
X1340 Von.t71 a_n10106_3341# VDD.t226 VDD.t1 sg13_lv_pmos ad=0.2603p pd=1.75u as=0.2603p ps=1.75u w=1.37u l=0.35u
X1341 Von.t88 a_n10106_3341# VDD.t198 VDD.t1 sg13_lv_pmos ad=0.2603p pd=1.75u as=0.2603p ps=1.75u w=1.37u l=0.35u
X1342 a_n3162_51# CMFBin.t18 VSS.t201 VSS.t202 sg13_lv_nmos ad=0.6327p pd=3.71u as=0.6327p ps=3.71u w=3.33u l=0.2u
X1343 Vop.t48 a_1220_1772# VDD.t348 VDD.t1 sg13_lv_pmos ad=0.2603p pd=1.75u as=0.2603p ps=1.75u w=1.37u l=0.35u
X1344 VDD.t784 a_n6543_n10895# a_n2002_n4396# VDD.t0 sg13_lv_pmos ad=0.19p pd=1.38u as=0.19p ps=1.38u w=1u l=0.7u
X1345 Vop.t8 a_n10179_n275# VSS.t124 VSS.t9 sg13_lv_nmos ad=0.912p pd=5.18u as=0.912p ps=5.18u w=4.8u l=1.06u
X1346 Von.t90 a_n10106_3341# VDD.t182 VDD.t1 sg13_lv_pmos ad=0.2603p pd=1.75u as=0.2603p ps=1.75u w=1.37u l=0.35u
X1347 VDD.t648 a_n14155_n5285# a_n14155_n5285# VDD.t642 sg13_lv_pmos ad=1.9p pd=10.38u as=1.9p ps=10.38u w=10u l=1u
X1348 CMFBout.t11 Vop.t158 a_n2002_n4396# VDD.t0 sg13_lv_pmos ad=0.24415p pd=1.665u as=0.24415p ps=1.665u w=1.285u l=0.35u
X1349 a_n2002_n4396# a_n6543_n10895# VDD.t982 VDD.t0 sg13_lv_pmos ad=0.19p pd=1.38u as=0.19p ps=1.38u w=1u l=0.7u
X1350 a_n3381_1772# a_n10013_2465# VDD.t26 VDD.t1 sg13_lv_pmos ad=1.33p pd=7.38u as=2.38p ps=14.68u w=7u l=0.7u
X1351 VDD.t695 a_n6543_n10895# a_n6543_n10895# VDD.t0 sg13_lv_pmos ad=0.19p pd=1.38u as=0.19p ps=1.38u w=1u l=0.7u
X1352 CMFBout.t8 Von.t158 a_n5006_n3441# VDD.t0 sg13_lv_pmos ad=0.24415p pd=1.665u as=0.24415p ps=1.665u w=1.285u l=0.35u
X1353 VSS.t156 a_n2373_n10895# VSS.t155 rppd l=11.5u w=1u
X1354 a_1220_1772# a_n9221_n275# a_881_4136# VDD.t1 sg13_lv_pmos ad=0.7695p pd=4.43u as=0.7695p ps=4.43u w=4.05u l=0.5u
X1355 a_n5006_n3441# a_n6543_n10895# VDD.t804 VDD.t0 sg13_lv_pmos ad=0.19p pd=1.38u as=0.19p ps=1.38u w=1u l=0.7u
X1356 a_n5006_n3441# a_n6543_n10895# VDD.t817 VDD.t0 sg13_lv_pmos ad=0.19p pd=1.38u as=0.19p ps=1.38u w=1u l=0.7u
X1357 Vop.t69 a_1220_1772# VDD.t548 VDD.t1 sg13_lv_pmos ad=0.2603p pd=1.75u as=0.2603p ps=1.75u w=1.37u l=0.35u
X1358 VDD.t444 a_1220_1772# Vop.t105 VDD.t1 sg13_lv_pmos ad=0.2603p pd=1.75u as=0.2603p ps=1.75u w=1.37u l=0.35u
X1359 a_n10106_3341# a_n8929_2739# a_n1828_1772# VSS.t322 sg13_lv_nmos ad=0.361p pd=2.28u as=0.646p ps=4.48u w=1.9u l=0.16u
X1360 a_n2002_n4396# a_n6543_n10895# VDD.t775 VDD.t0 sg13_lv_pmos ad=0.19p pd=1.38u as=0.19p ps=1.38u w=1u l=0.7u
X1361 a_n3381_1772# a_n9221_n275# a_n10106_3341# VDD.t1 sg13_lv_pmos ad=0.7695p pd=4.43u as=0.7695p ps=4.43u w=4.05u l=0.5u
X1362 VOUTP.t20 a_13228_n9920# VDD.t597 VSS.t167 sg13_lv_nmos ad=3.4p pd=20.68u as=3.4p ps=20.68u w=10u l=0.15u
X1363 a_n1828_1772# a_n8929_2739# a_n10106_3341# VSS.t327 sg13_lv_nmos ad=0.646p pd=4.48u as=0.361p ps=2.28u w=1.9u l=0.16u
X1364 Von.t68 a_n10106_3341# VDD.t135 VDD.t1 sg13_lv_pmos ad=0.2603p pd=1.75u as=0.4658p ps=3.42u w=1.37u l=0.35u
X1365 VDD.t618 a_13228_n9920# VOUTP.t11 VSS.t172 sg13_lv_nmos ad=3.4p pd=20.68u as=3.4p ps=20.68u w=10u l=0.15u
X1366 VDD.t88 a_n20570_n9414# VOUTN.t0 VSS.t134 sg13_lv_nmos ad=3.4p pd=20.68u as=3.4p ps=20.68u w=10u l=0.15u
X1367 Von.t141 a_n10106_3341# VDD.t340 VDD.t1 sg13_lv_pmos ad=0.2603p pd=1.75u as=0.2603p ps=1.75u w=1.37u l=0.35u
X1368 a_n2002_n4396# a_n6543_n10895# VDD.t916 VDD.t0 sg13_lv_pmos ad=0.19p pd=1.38u as=0.19p ps=1.38u w=1u l=0.7u
X1369 VSS.t289 CMFBout.t30 CMFBout.t33 VSS.t288 sg13_lv_nmos ad=0.6327p pd=3.71u as=0.6327p ps=3.71u w=3.33u l=0.2u
X1370 a_n20570_n9414# VOUTN.t26 a_n14528_n9920# VSS.t259 sg13_lv_nmos ad=1.9p pd=10.38u as=1.9p ps=10.38u w=10u l=0.5u
X1371 Von.t37 a_n10106_3341# VDD.t268 VDD.t1 sg13_lv_pmos ad=0.2603p pd=1.75u as=0.2603p ps=1.75u w=1.37u l=0.35u
X1372 VSS.t38 a_n10179_n275# Von.t2 VSS.t26 sg13_lv_nmos ad=1.632p pd=10.28u as=0.912p ps=5.18u w=4.8u l=1.06u
X1373 a_36_n4396# VREF.t0 a_n5006_n3441# VDD.t0 sg13_lv_pmos ad=0.24415p pd=1.665u as=0.24415p ps=1.665u w=1.285u l=0.35u
X1374 a_13228_n9920# VOUTP.t26 a_11652_n9920# VSS.t4 sg13_lv_nmos ad=1.9p pd=10.38u as=1.9p ps=10.38u w=10u l=0.5u
X1375 VDD.t763 a_n6543_n10895# a_n5006_n3441# VDD.t0 sg13_lv_pmos ad=0.19p pd=1.38u as=0.19p ps=1.38u w=1u l=0.7u
X1376 VDD.t292 a_n10106_3341# Von.t125 VDD.t1 sg13_lv_pmos ad=0.2603p pd=1.75u as=0.2603p ps=1.75u w=1.37u l=0.35u
X1377 a_n5006_n3441# Von.t158 CMFBout.t25 VDD.t0 sg13_lv_pmos ad=0.24415p pd=1.665u as=0.24415p ps=1.665u w=1.285u l=0.35u
X1378 Vop.t77 a_1220_1772# VDD.t462 VDD.t1 sg13_lv_pmos ad=0.2603p pd=1.75u as=0.2603p ps=1.75u w=1.37u l=0.35u
X1379 a_n3162_51# CMFBin.t0 VSS.t255 VSS.t256 sg13_lv_nmos ad=1.1322p pd=7.34u as=0.6327p ps=3.71u w=3.33u l=0.2u
X1380 VDD.t904 a_n6543_n10895# a_n5006_n3441# VDD.t0 sg13_lv_pmos ad=0.19p pd=1.38u as=0.19p ps=1.38u w=1u l=0.7u
X1381 a_36_n4396# VREF.t0 a_n5006_n3441# VDD.t0 sg13_lv_pmos ad=0.24415p pd=1.665u as=0.24415p ps=1.665u w=1.285u l=0.35u
X1382 Vop.t122 a_1220_1772# VDD.t394 VDD.t1 sg13_lv_pmos ad=0.2603p pd=1.75u as=0.2603p ps=1.75u w=1.37u l=0.35u
X1383 VOUTP.t17 a_13228_n9920# VDD.t615 VSS.t169 sg13_lv_nmos ad=3.4p pd=20.68u as=3.4p ps=20.68u w=10u l=0.15u
X1384 VDD.t838 a_n6543_n10895# a_n2002_n4396# VDD.t0 sg13_lv_pmos ad=0.19p pd=1.38u as=0.19p ps=1.38u w=1u l=0.7u
X1385 VDD.t39 a_n10013_2465# a_n3381_1772# VDD.t1 sg13_lv_pmos ad=2.38p pd=14.68u as=1.33p ps=7.38u w=7u l=0.7u
X1386 VDD.t226 a_n10106_3341# Von.t106 VDD.t1 sg13_lv_pmos ad=0.2603p pd=1.75u as=0.2603p ps=1.75u w=1.37u l=0.35u
X1387 VSS.t219 CMFBin.t12 a_n3162_51# VSS.t218 sg13_lv_nmos ad=0.6327p pd=3.71u as=0.6327p ps=3.71u w=3.33u l=0.2u
X1388 a_n1828_1772# a_n8929_2739# a_n10106_3341# VSS.t327 sg13_lv_nmos ad=0.646p pd=4.48u as=0.361p ps=2.28u w=1.9u l=0.16u
X1389 VDD.t198 a_n10106_3341# Von.t87 VDD.t1 sg13_lv_pmos ad=0.2603p pd=1.75u as=0.2603p ps=1.75u w=1.37u l=0.35u
X1390 a_n2002_n4396# a_n6543_n10895# VDD.t827 VDD.t0 sg13_lv_pmos ad=0.19p pd=1.38u as=0.19p ps=1.38u w=1u l=0.7u
X1391 Vop.t138 a_1220_1772# VDD.t530 VDD.t1 sg13_lv_pmos ad=0.2603p pd=1.75u as=0.2603p ps=1.75u w=1.37u l=0.35u
X1392 VDD.t683 a_n6543_n10895# a_n6543_n10895# VDD.t0 sg13_lv_pmos ad=0.19p pd=1.38u as=0.19p ps=1.38u w=1u l=0.7u
X1393 Vop.t59 a_1220_1772# VDD.t498 VDD.t1 sg13_lv_pmos ad=0.2603p pd=1.75u as=0.2603p ps=1.75u w=1.37u l=0.35u
X1394 VDD.t262 a_n10106_3341# Von.t42 VDD.t1 sg13_lv_pmos ad=0.2603p pd=1.75u as=0.2603p ps=1.75u w=1.37u l=0.35u
X1395 a_n3162_51# CMFBin.t22 VSS.t189 VSS.t190 sg13_lv_nmos ad=0.6327p pd=3.71u as=0.6327p ps=3.71u w=3.33u l=0.2u
X1396 VDD.t980 a_n6543_n10895# a_n2002_n4396# VDD.t0 sg13_lv_pmos ad=0.19p pd=1.38u as=0.19p ps=1.38u w=1u l=0.7u
X1397 a_n2002_n4396# a_n6543_n10895# VDD.t731 VDD.t0 sg13_lv_pmos ad=0.19p pd=1.38u as=0.19p ps=1.38u w=1u l=0.7u
X1398 Vop.t125 a_1220_1772# VDD.t407 VDD.t1 sg13_lv_pmos ad=0.2603p pd=1.75u as=0.4658p ps=3.42u w=1.37u l=0.35u
X1399 VDD.t174 a_n10106_3341# Von.t152 VDD.t1 sg13_lv_pmos ad=0.4658p pd=3.42u as=0.2603p ps=1.75u w=1.37u l=0.35u
X1400 a_n6543_n10895# a_n6543_n10895# VDD.t658 VDD.t0 sg13_lv_pmos ad=0.19p pd=1.38u as=0.34p ps=2.68u w=1u l=0.7u
X1401 a_n2002_n4396# VREF.t0 a_36_n4396# VDD.t0 sg13_lv_pmos ad=0.24415p pd=1.665u as=0.24415p ps=1.665u w=1.285u l=0.35u
X1402 Von.t8 a_n10179_n275# VSS.t98 VSS.t16 sg13_lv_nmos ad=0.912p pd=5.18u as=0.912p ps=5.18u w=4.8u l=1.06u
X1403 a_n2002_n4396# a_n6543_n10895# VDD.t935 VDD.t0 sg13_lv_pmos ad=0.19p pd=1.38u as=0.19p ps=1.38u w=1u l=0.7u
X1404 a_n2002_n4396# VREF.t0 a_36_n4396# VDD.t0 sg13_lv_pmos ad=0.24415p pd=1.665u as=0.24415p ps=1.665u w=1.285u l=0.35u
X1405 VDD.t717 a_n6543_n10895# a_n5006_n3441# VDD.t0 sg13_lv_pmos ad=0.19p pd=1.38u as=0.19p ps=1.38u w=1u l=0.7u
X1406 VDD.t345 a_n9221_n275# a_n9221_n275# VDD.t1 sg13_lv_pmos ad=0.3895p pd=2.43u as=0.697p ps=4.78u w=2.05u l=0.35u
X1407 Vop.t5 a_n10179_n275# VSS.t70 VSS.t9 sg13_lv_nmos ad=0.912p pd=5.18u as=0.912p ps=5.18u w=4.8u l=1.06u
X1408 VDD.t482 a_1220_1772# Vop.t91 VDD.t1 sg13_lv_pmos ad=0.2603p pd=1.75u as=0.2603p ps=1.75u w=1.37u l=0.35u
X1409 a_n3162_51# VNin.t0 a_286_1773# VSS.t147 sg13_lv_nmos ad=0.374p pd=2.88u as=0.209p ps=1.48u w=1.1u l=0.15u
X1410 VDD.t416 a_1220_1772# Vop.t102 VDD.t1 sg13_lv_pmos ad=0.4658p pd=3.42u as=0.2603p ps=1.75u w=1.37u l=0.35u
X1411 VDD.t450 a_1220_1772# Vop.t87 VDD.t1 sg13_lv_pmos ad=0.2603p pd=1.75u as=0.2603p ps=1.75u w=1.37u l=0.35u
X1412 a_n2373_n10895# a_n6543_n9623# a_n3721_n10895# VSS.t317 sg13_lv_nmos ad=1.14p pd=6.38u as=1.14p ps=6.38u w=6u l=6.4u
X1413 a_11652_n9920# IB.t1 VSS.t277 VSS.t282 sg13_lv_nmos ad=1.02p pd=6.68u as=0.57p ps=3.38u w=3u l=1u
X1414 a_n14155_n5285# Von.t157 a_n14528_n9920# VSS.t301 sg13_lv_nmos ad=1.9p pd=10.38u as=1.9p ps=10.38u w=10u l=0.5u
X1415 VSS.t240 CMFBin.t5 a_n3162_51# VSS.t239 sg13_lv_nmos ad=0.6327p pd=3.71u as=0.6327p ps=3.71u w=3.33u l=0.2u
X1416 VDD.t55 a_n10013_2465# a_881_4136# VDD.t1 sg13_lv_pmos ad=1.33p pd=7.38u as=1.33p ps=7.38u w=7u l=0.7u
X1417 VDD.t268 a_n10106_3341# Von.t36 VDD.t1 sg13_lv_pmos ad=0.2603p pd=1.75u as=0.2603p ps=1.75u w=1.37u l=0.35u
X1418 VDD.t5 a_n10013_2465# a_n3381_1772# VDD.t1 sg13_lv_pmos ad=1.33p pd=7.38u as=1.33p ps=7.38u w=7u l=0.7u
X1419 Vop.t1 a_n10179_n275# VSS.t87 VSS.t9 sg13_lv_nmos ad=0.912p pd=5.18u as=0.912p ps=5.18u w=4.8u l=1.06u
X1420 VSS.t64 a_n10179_n275# Vop.t14 VSS.t63 sg13_lv_nmos ad=0.912p pd=5.18u as=0.912p ps=5.18u w=4.8u l=1.06u
X1421 Vop.t40 a_1220_1772# VDD.t568 VDD.t1 sg13_lv_pmos ad=0.2603p pd=1.75u as=0.2603p ps=1.75u w=1.37u l=0.35u
X1422 a_n6543_n9623# a_n3721_n10895# VDD.t625 VDD.t622 sg13_lv_pmos ad=1.14p pd=6.38u as=2.04p ps=12.68u w=6u l=2.5u
X1423 VDD.t940 a_n6543_n10895# a_n5006_n3441# VDD.t0 sg13_lv_pmos ad=0.19p pd=1.38u as=0.19p ps=1.38u w=1u l=0.7u
X1424 a_n2002_n4396# a_n6543_n10895# VDD.t835 VDD.t0 sg13_lv_pmos ad=0.19p pd=1.38u as=0.19p ps=1.38u w=1u l=0.7u
X1425 a_n2002_n4396# a_n6543_n10895# VDD.t749 VDD.t0 sg13_lv_pmos ad=0.19p pd=1.38u as=0.19p ps=1.38u w=1u l=0.7u
X1426 a_11820_n9920# Vop.t157 a_11652_n9920# VSS.t161 sg13_lv_nmos ad=1.9p pd=10.38u as=1.9p ps=10.38u w=10u l=0.5u
X1427 a_n5006_n3441# a_n6543_n10895# VDD.t771 VDD.t0 sg13_lv_pmos ad=0.19p pd=1.38u as=0.19p ps=1.38u w=1u l=0.7u
X1428 VDD.t126 a_n10106_3341# Von.t114 VDD.t1 sg13_lv_pmos ad=0.2603p pd=1.75u as=0.2603p ps=1.75u w=1.37u l=0.35u
X1429 a_n1828_1772# VPin.t0 a_n3162_51# VSS.t149 sg13_lv_nmos ad=0.209p pd=1.48u as=0.374p ps=2.88u w=1.1u l=0.15u
X1430 VDD.t464 a_1220_1772# Vop.t77 VDD.t1 sg13_lv_pmos ad=0.2603p pd=1.75u as=0.2603p ps=1.75u w=1.37u l=0.35u
X1431 a_1220_1772# a_n8929_2739# a_286_1773# VSS.t332 sg13_lv_nmos ad=0.361p pd=2.28u as=0.361p ps=2.28u w=1.9u l=0.16u
X1432 VDD.t408 a_1220_1772# Vop.t125 VDD.t1 sg13_lv_pmos ad=0.2603p pd=1.75u as=0.2603p ps=1.75u w=1.37u l=0.35u
X1433 VDD.t520 a_1220_1772# Vop.t66 VDD.t1 sg13_lv_pmos ad=0.2603p pd=1.75u as=0.2603p ps=1.75u w=1.37u l=0.35u
X1434 VDD.t933 a_n6543_n10895# a_n2002_n4396# VDD.t0 sg13_lv_pmos ad=0.19p pd=1.38u as=0.19p ps=1.38u w=1u l=0.7u
X1435 a_881_4136# a_n9221_n275# a_1220_1772# VDD.t1 sg13_lv_pmos ad=0.7695p pd=4.43u as=0.7695p ps=4.43u w=4.05u l=0.5u
X1436 a_n3162_51# VNin.t0 a_286_1773# VSS.t147 sg13_lv_nmos ad=0.374p pd=2.88u as=0.209p ps=1.48u w=1.1u l=0.15u
X1437 Von.t87 a_n10106_3341# VDD.t196 VDD.t1 sg13_lv_pmos ad=0.2603p pd=1.75u as=0.2603p ps=1.75u w=1.37u l=0.35u
X1438 a_n2002_n4396# a_n6543_n10895# VDD.t873 VDD.t0 sg13_lv_pmos ad=0.19p pd=1.38u as=0.19p ps=1.38u w=1u l=0.7u
X1439 VSS.t192 CMFBin.t21 a_n3162_51# VSS.t191 sg13_lv_nmos ad=0.6327p pd=3.71u as=0.6327p ps=3.71u w=3.33u l=0.2u
X1440 Von.t110 a_n10106_3341# VDD.t152 VDD.t1 sg13_lv_pmos ad=0.2603p pd=1.75u as=0.2603p ps=1.75u w=1.37u l=0.35u
X1441 a_n3162_51# CMFBin.t13 VSS.t216 VSS.t217 sg13_lv_nmos ad=0.6327p pd=3.71u as=0.6327p ps=3.71u w=3.33u l=0.2u
X1442 VDD.t630 a_n3721_n10895# a_n13845_n10915# VDD.t622 sg13_lv_pmos ad=1.14p pd=6.38u as=1.14p ps=6.38u w=6u l=2.5u
X1443 a_n10106_3341# a_n9221_n275# a_n3381_1772# VDD.t1 sg13_lv_pmos ad=0.7695p pd=4.43u as=0.7695p ps=4.43u w=4.05u l=0.5u
X1444 a_n2002_n4396# a_n6543_n10895# VDD.t984 VDD.t0 sg13_lv_pmos ad=0.19p pd=1.38u as=0.19p ps=1.38u w=1u l=0.7u
X1445 Vop.t92 a_1220_1772# VDD.t482 VDD.t1 sg13_lv_pmos ad=0.2603p pd=1.75u as=0.2603p ps=1.75u w=1.37u l=0.35u
X1446 VDD.t378 a_1220_1772# Vop.t116 VDD.t1 sg13_lv_pmos ad=0.2603p pd=1.75u as=0.2603p ps=1.75u w=1.37u l=0.35u
X1447 a_n2002_n4396# a_n6543_n10895# VDD.t970 VDD.t0 sg13_lv_pmos ad=0.19p pd=1.38u as=0.19p ps=1.38u w=1u l=0.7u
X1448 VOUTP.t24 a_13228_n9920# VDD.t601 VSS.t171 sg13_lv_nmos ad=3.4p pd=20.68u as=3.4p ps=20.68u w=10u l=0.15u
X1449 a_n5006_n3441# a_n6543_n10895# VDD.t776 VDD.t0 sg13_lv_pmos ad=0.19p pd=1.38u as=0.19p ps=1.38u w=1u l=0.7u
X1450 a_1220_1772# a_n8929_2739# a_286_1773# VSS.t332 sg13_lv_nmos ad=0.361p pd=2.28u as=0.361p ps=2.28u w=1.9u l=0.16u
X1451 VSS.t82 a_n10179_n275# Vop.t3 VSS.t9 sg13_lv_nmos ad=0.912p pd=5.18u as=0.912p ps=5.18u w=4.8u l=1.06u
X1452 VDD.t35 a_n10013_2465# a_n3381_1772# VDD.t1 sg13_lv_pmos ad=1.33p pd=7.38u as=1.33p ps=7.38u w=7u l=0.7u
X1453 a_881_4136# a_n9221_n275# a_1220_1772# VDD.t1 sg13_lv_pmos ad=0.7695p pd=4.43u as=0.7695p ps=4.43u w=4.05u l=0.5u
X1454 VDD.t986 a_n6543_n10895# a_n2002_n4396# VDD.t0 sg13_lv_pmos ad=0.34p pd=2.68u as=0.19p ps=1.38u w=1u l=0.7u
X1455 CMFBout.t4 Vop.t158 a_n2002_n4396# VDD.t0 sg13_lv_pmos ad=0.24415p pd=1.665u as=0.24415p ps=1.665u w=1.285u l=0.35u
X1456 a_3041_6527# a_1220_1772# VSS.t148 rppd l=0.55u w=1.5u
X1457 Vop.t134 a_1220_1772# VDD.t550 VDD.t1 sg13_lv_pmos ad=0.2603p pd=1.75u as=0.2603p ps=1.75u w=1.37u l=0.35u
X1458 VOUTP.t15 a_13228_n9920# VDD.t621 VSS.t175 sg13_lv_nmos ad=3.4p pd=20.68u as=3.4p ps=20.68u w=10u l=0.15u
X1459 a_n10106_3341# a_n9221_n275# a_n3381_1772# VDD.t1 sg13_lv_pmos ad=0.7695p pd=4.43u as=0.7695p ps=4.43u w=4.05u l=0.5u
X1460 a_n1828_1772# VPin.t0 a_n3162_51# VSS.t149 sg13_lv_nmos ad=0.209p pd=1.48u as=0.374p ps=2.88u w=1.1u l=0.15u
X1461 VDD.t380 a_1220_1772# Vop.t154 VDD.t1 sg13_lv_pmos ad=0.2603p pd=1.75u as=0.2603p ps=1.75u w=1.37u l=0.35u
X1462 VDD.t871 a_n6543_n10895# a_n2002_n4396# VDD.t0 sg13_lv_pmos ad=0.19p pd=1.38u as=0.19p ps=1.38u w=1u l=0.7u
X1463 VDD.t747 a_n6543_n10895# a_n2002_n4396# VDD.t0 sg13_lv_pmos ad=0.19p pd=1.38u as=0.19p ps=1.38u w=1u l=0.7u
X1464 VOUTP.t4 a_13228_n9920# VDD.t619 VSS.t173 sg13_lv_nmos ad=3.4p pd=20.68u as=3.4p ps=20.68u w=10u l=0.15u
X1465 a_881_4136# a_n10013_2465# VDD.t59 VDD.t1 sg13_lv_pmos ad=1.33p pd=7.38u as=1.33p ps=7.38u w=7u l=0.7u
X1466 Vop.t104 a_1220_1772# VDD.t427 VDD.t1 sg13_lv_pmos ad=0.2603p pd=1.75u as=0.4658p ps=3.42u w=1.37u l=0.35u
X1467 VDD.t376 a_1220_1772# Vop.t115 VDD.t1 sg13_lv_pmos ad=0.4658p pd=3.42u as=0.2603p ps=1.75u w=1.37u l=0.35u
X1468 VDD.t892 a_n6543_n10895# a_n5006_n3441# VDD.t0 sg13_lv_pmos ad=0.19p pd=1.38u as=0.19p ps=1.38u w=1u l=0.7u
X1469 Von.t121 a_n10106_3341# VDD.t310 VDD.t1 sg13_lv_pmos ad=0.2603p pd=1.75u as=0.2603p ps=1.75u w=1.37u l=0.35u
X1470 CMFBout.t36 CMFBout.t30 VSS.t295 VSS.t296 sg13_lv_nmos ad=0.6327p pd=3.71u as=0.6327p ps=3.71u w=3.33u l=0.2u
X1471 Von.t36 a_n10106_3341# VDD.t266 VDD.t1 sg13_lv_pmos ad=0.2603p pd=1.75u as=0.2603p ps=1.75u w=1.37u l=0.35u
X1472 a_n5006_n3441# a_n6543_n10895# VDD.t821 VDD.t0 sg13_lv_pmos ad=0.19p pd=1.38u as=0.19p ps=1.38u w=1u l=0.7u
X1473 VSS.t49 a_n10179_n275# Von.t23 VSS.t26 sg13_lv_nmos ad=1.632p pd=10.28u as=0.912p ps=5.18u w=4.8u l=1.06u
X1474 VDD.t290 a_n10106_3341# Von.t49 VDD.t1 sg13_lv_pmos ad=0.2603p pd=1.75u as=0.2603p ps=1.75u w=1.37u l=0.35u
X1475 VSS.t345 a_36_n4396# a_36_n4396# VSS.t344 sg13_lv_nmos ad=0.6327p pd=3.71u as=0.6327p ps=3.71u w=3.33u l=0.2u
X1476 Von.t107 a_n10106_3341# VDD.t222 VDD.t1 sg13_lv_pmos ad=0.2603p pd=1.75u as=0.2603p ps=1.75u w=1.37u l=0.35u
X1477 VDD.t436 a_1220_1772# Vop.t142 VDD.t1 sg13_lv_pmos ad=0.4658p pd=3.42u as=0.2603p ps=1.75u w=1.37u l=0.35u
X1478 a_n5006_n3441# a_n6543_n10895# VDD.t759 VDD.t0 sg13_lv_pmos ad=0.19p pd=1.38u as=0.19p ps=1.38u w=1u l=0.7u
X1479 VSS.t126 a_n10179_n275# Vop.t8 VSS.t9 sg13_lv_nmos ad=0.912p pd=5.18u as=0.912p ps=5.18u w=4.8u l=1.06u
X1480 VDD.t196 a_n10106_3341# Von.t92 VDD.t1 sg13_lv_pmos ad=0.2603p pd=1.75u as=0.2603p ps=1.75u w=1.37u l=0.35u
X1481 a_n5006_n3441# Von.t158 CMFBout.t22 VDD.t0 sg13_lv_pmos ad=0.24415p pd=1.665u as=0.24415p ps=1.665u w=1.285u l=0.35u
X1482 a_n3162_51# CMFBin.t9 VSS.t228 VSS.t229 sg13_lv_nmos ad=0.6327p pd=3.71u as=0.6327p ps=3.71u w=3.33u l=0.2u
X1483 Von.t119 a_n10106_3341# VDD.t110 VDD.t1 sg13_lv_pmos ad=0.2603p pd=1.75u as=0.2603p ps=1.75u w=1.37u l=0.35u
X1484 a_n5006_n3441# Von.t158 CMFBout.t19 VDD.t0 sg13_lv_pmos ad=0.24415p pd=1.665u as=0.24415p ps=1.665u w=1.285u l=0.35u
X1485 a_286_1773# a_n8929_2739# a_1220_1772# VSS.t331 sg13_lv_nmos ad=0.361p pd=2.28u as=0.361p ps=2.28u w=1.9u l=0.16u
X1486 Vop.t60 a_1220_1772# VDD.t500 VDD.t1 sg13_lv_pmos ad=0.2603p pd=1.75u as=0.2603p ps=1.75u w=1.37u l=0.35u
X1487 VDD.t260 a_n10106_3341# Von.t97 VDD.t1 sg13_lv_pmos ad=0.2603p pd=1.75u as=0.2603p ps=1.75u w=1.37u l=0.35u
X1488 VSS.t279 IB.t1 IB.t2 VSS.t278 sg13_lv_nmos ad=1.02p pd=6.68u as=1.02p ps=6.68u w=3u l=1u
X1489 Vop.t34 a_1220_1772# VDD.t588 VDD.t1 sg13_lv_pmos ad=0.2603p pd=1.75u as=0.2603p ps=1.75u w=1.37u l=0.35u
X1490 VDD.t652 a_n6543_n10895# a_n5006_n3441# VDD.t0 sg13_lv_pmos ad=0.19p pd=1.38u as=0.19p ps=1.38u w=1u l=0.7u
X1491 VDD.t356 a_1220_1772# Vop.t46 VDD.t1 sg13_lv_pmos ad=0.4658p pd=3.42u as=0.2603p ps=1.75u w=1.37u l=0.35u
X1492 VSS.t237 CMFBin.t6 a_n3162_51# VSS.t236 sg13_lv_nmos ad=0.6327p pd=3.71u as=0.6327p ps=3.71u w=3.33u l=0.2u
X1493 VDD.t944 a_n6543_n10895# a_n5006_n3441# VDD.t0 sg13_lv_pmos ad=0.19p pd=1.38u as=0.19p ps=1.38u w=1u l=0.7u
X1494 Vop.t25 a_n10179_n275# VSS.t117 VSS.t61 sg13_lv_nmos ad=0.912p pd=5.18u as=1.632p ps=10.28u w=4.8u l=1.06u
X1495 a_n6543_n10895# a_n6543_n10895# VDD.t669 VDD.t0 sg13_lv_pmos ad=0.19p pd=1.38u as=0.19p ps=1.38u w=1u l=0.7u
X1496 VDD.t144 a_n10106_3341# Von.t56 VDD.t1 sg13_lv_pmos ad=0.4658p pd=3.42u as=0.2603p ps=1.75u w=1.37u l=0.35u
X1497 a_n2002_n4396# a_n6543_n10895# VDD.t937 VDD.t0 sg13_lv_pmos ad=0.19p pd=1.38u as=0.19p ps=1.38u w=1u l=0.7u
X1498 a_n2002_n4396# a_n6543_n10895# VDD.t922 VDD.t0 sg13_lv_pmos ad=0.19p pd=1.38u as=0.19p ps=1.38u w=1u l=0.7u
X1499 a_36_n4396# VREF.t0 a_n5006_n3441# VDD.t0 sg13_lv_pmos ad=0.24415p pd=1.665u as=0.24415p ps=1.665u w=1.285u l=0.35u
X1500 a_n5006_n3441# VREF.t0 a_36_n4396# VDD.t0 sg13_lv_pmos ad=0.24415p pd=1.665u as=0.24415p ps=1.665u w=1.285u l=0.35u
X1501 a_286_1773# VNin.t0 a_n3162_51# VSS.t146 sg13_lv_nmos ad=0.209p pd=1.48u as=0.209p ps=1.48u w=1.1u l=0.15u
X1502 a_286_1773# a_n8929_2739# a_1220_1772# VSS.t331 sg13_lv_nmos ad=0.361p pd=2.28u as=0.361p ps=2.28u w=1.9u l=0.16u
X1503 VDD.t484 a_1220_1772# Vop.t92 VDD.t1 sg13_lv_pmos ad=0.2603p pd=1.75u as=0.2603p ps=1.75u w=1.37u l=0.35u
X1504 a_n20570_n9414# VOUTN.t26 a_n14528_n9920# VSS.t261 sg13_lv_nmos ad=1.9p pd=10.38u as=1.9p ps=10.38u w=10u l=0.5u
X1505 VSS.t52 a_n10179_n275# Von.t6 VSS.t14 sg13_lv_nmos ad=0.912p pd=5.18u as=0.912p ps=5.18u w=4.8u l=1.06u
X1506 Von.t21 a_n10179_n275# VSS.t32 VSS.t19 sg13_lv_nmos ad=0.912p pd=5.18u as=0.912p ps=5.18u w=4.8u l=1.06u
X1507 VDD.t939 a_n6543_n10895# a_n2002_n4396# VDD.t0 sg13_lv_pmos ad=0.34p pd=2.68u as=0.19p ps=1.38u w=1u l=0.7u
X1508 a_n2002_n4396# VREF.t0 a_36_n4396# VDD.t0 sg13_lv_pmos ad=0.24415p pd=1.665u as=0.24415p ps=1.665u w=1.285u l=0.35u
X1509 VDD.t452 a_1220_1772# Vop.t88 VDD.t1 sg13_lv_pmos ad=0.2603p pd=1.75u as=0.2603p ps=1.75u w=1.37u l=0.35u
X1510 VDD.t428 a_1220_1772# Vop.t104 VDD.t1 sg13_lv_pmos ad=0.2603p pd=1.75u as=0.2603p ps=1.75u w=1.37u l=0.35u
X1511 a_11652_n9920# VOUTP.t26 a_13228_n9920# VSS.t7 sg13_lv_nmos ad=3.4p pd=20.68u as=1.9p ps=10.38u w=10u l=0.5u
X1512 VDD.t859 a_n6543_n10895# a_n5006_n3441# VDD.t0 sg13_lv_pmos ad=0.19p pd=1.38u as=0.19p ps=1.38u w=1u l=0.7u
X1513 VDD.t266 a_n10106_3341# Von.t40 VDD.t1 sg13_lv_pmos ad=0.2603p pd=1.75u as=0.2603p ps=1.75u w=1.37u l=0.35u
X1514 VDD.t11 a_n10013_2465# a_n3381_1772# VDD.t1 sg13_lv_pmos ad=1.33p pd=7.38u as=1.33p ps=7.38u w=7u l=0.7u
X1515 a_13228_n9920# VOUTP.t26 a_11652_n9920# VSS.t0 sg13_lv_nmos ad=1.9p pd=10.38u as=1.9p ps=10.38u w=10u l=0.5u
X1516 a_n3162_51# VNin.t0 a_286_1773# VSS.t145 sg13_lv_nmos ad=0.209p pd=1.48u as=0.209p ps=1.48u w=1.1u l=0.15u
X1517 VDD.t703 a_n6543_n10895# a_n6543_n10895# VDD.t0 sg13_lv_pmos ad=0.19p pd=1.38u as=0.19p ps=1.38u w=1u l=0.7u
X1518 VDD.t637 a_11820_n9920# a_11820_n9920# VDD.t633 sg13_lv_pmos ad=1.9p pd=10.38u as=1.9p ps=10.38u w=10u l=1u
X1519 a_n6543_n10895# a_n6543_n9623# VSS.t319 VSS.t310 sg13_lv_nmos ad=2.04p pd=12.68u as=1.14p ps=6.38u w=6u l=6.4u
X1520 Vop.t33 a_1220_1772# VDD.t570 VDD.t1 sg13_lv_pmos ad=0.2603p pd=1.75u as=0.2603p ps=1.75u w=1.37u l=0.35u
X1521 Von.t26 a_n10179_n275# VSS.t58 VSS.t25 sg13_lv_nmos ad=0.912p pd=5.18u as=0.912p ps=5.18u w=4.8u l=1.06u
X1522 a_n2002_n4396# a_n6543_n10895# VDD.t751 VDD.t0 sg13_lv_pmos ad=0.19p pd=1.38u as=0.19p ps=1.38u w=1u l=0.7u
X1523 a_n2002_n4396# a_n6543_n10895# VDD.t737 VDD.t0 sg13_lv_pmos ad=0.19p pd=1.38u as=0.19p ps=1.38u w=1u l=0.7u
X1524 Von.t147 a_n10106_3341# VDD.t155 VDD.t1 sg13_lv_pmos ad=0.2603p pd=1.75u as=0.4658p ps=3.42u w=1.37u l=0.35u
X1525 VSS.t195 CMFBin.t20 a_n3162_51# VSS.t194 sg13_lv_nmos ad=0.6327p pd=3.71u as=0.6327p ps=3.71u w=3.33u l=0.2u
X1526 VDD.t865 a_n6543_n10895# a_n5006_n3441# VDD.t0 sg13_lv_pmos ad=0.19p pd=1.38u as=0.19p ps=1.38u w=1u l=0.7u
X1527 Von.t49 a_n10106_3341# VDD.t288 VDD.t1 sg13_lv_pmos ad=0.2603p pd=1.75u as=0.2603p ps=1.75u w=1.37u l=0.35u
X1528 VDD.t362 a_1220_1772# Vop.t51 VDD.t1 sg13_lv_pmos ad=0.2603p pd=1.75u as=0.2603p ps=1.75u w=1.37u l=0.35u
X1529 a_36_n4396# VREF.t0 a_n2002_n4396# VDD.t0 sg13_lv_pmos ad=0.24415p pd=1.665u as=0.24415p ps=1.665u w=1.285u l=0.35u
X1530 VDD.t753 a_n6543_n10895# a_n2002_n4396# VDD.t0 sg13_lv_pmos ad=0.34p pd=2.68u as=0.19p ps=1.38u w=1u l=0.7u
X1531 VDD.t120 a_n10106_3341# Von.t55 VDD.t1 sg13_lv_pmos ad=0.2603p pd=1.75u as=0.2603p ps=1.75u w=1.37u l=0.35u
X1532 a_n2002_n4396# a_n6543_n10895# VDD.t885 VDD.t0 sg13_lv_pmos ad=0.19p pd=1.38u as=0.19p ps=1.38u w=1u l=0.7u
X1533 Vop.t102 a_1220_1772# VDD.t414 VDD.t1 sg13_lv_pmos ad=0.2603p pd=1.75u as=0.2603p ps=1.75u w=1.37u l=0.35u
X1534 VDD.t729 a_n6543_n10895# a_n5006_n3441# VDD.t0 sg13_lv_pmos ad=0.19p pd=1.38u as=0.19p ps=1.38u w=1u l=0.7u
X1535 a_n2373_n10895# a_n6543_n9623# a_n3721_n10895# VSS.t317 sg13_lv_nmos ad=1.14p pd=6.38u as=1.14p ps=6.38u w=6u l=6.4u
X1536 a_1220_1772# a_n8929_2739# a_286_1773# VSS.t330 sg13_lv_nmos ad=0.361p pd=2.28u as=0.361p ps=2.28u w=1.9u l=0.16u
X1537 VDD.t522 a_1220_1772# Vop.t67 VDD.t1 sg13_lv_pmos ad=0.2603p pd=1.75u as=0.2603p ps=1.75u w=1.37u l=0.35u
X1538 a_n1828_1772# VPin.t0 a_n3162_51# VSS.t151 sg13_lv_nmos ad=0.209p pd=1.48u as=0.209p ps=1.48u w=1.1u l=0.15u
X1539 Von.t62 a_n10106_3341# VDD.t330 VDD.t1 sg13_lv_pmos ad=0.2603p pd=1.75u as=0.2603p ps=1.75u w=1.37u l=0.35u
X1540 VDD.t896 a_n6543_n10895# a_n5006_n3441# VDD.t0 sg13_lv_pmos ad=0.19p pd=1.38u as=0.19p ps=1.38u w=1u l=0.7u
X1541 a_n3162_51# VPin.t0 a_n1828_1772# VSS.t152 sg13_lv_nmos ad=0.209p pd=1.48u as=0.209p ps=1.48u w=1.1u l=0.15u
X1542 Von.t97 a_n10106_3341# VDD.t258 VDD.t1 sg13_lv_pmos ad=0.2603p pd=1.75u as=0.2603p ps=1.75u w=1.37u l=0.35u
X1543 VDD.t282 a_n10106_3341# Von.t47 VDD.t1 sg13_lv_pmos ad=0.2603p pd=1.75u as=0.2603p ps=1.75u w=1.37u l=0.35u
X1544 Von.t70 a_n10106_3341# VDD.t242 VDD.t1 sg13_lv_pmos ad=0.2603p pd=1.75u as=0.2603p ps=1.75u w=1.37u l=0.35u
X1545 Vop.t89 a_1220_1772# VDD.t452 VDD.t1 sg13_lv_pmos ad=0.2603p pd=1.75u as=0.2603p ps=1.75u w=1.37u l=0.35u
X1546 VSS.t93 a_n10179_n275# Vop.t10 VSS.t9 sg13_lv_nmos ad=0.912p pd=5.18u as=0.912p ps=5.18u w=4.8u l=1.06u
X1547 a_1220_1772# a_n8929_2739# a_286_1773# VSS.t330 sg13_lv_nmos ad=0.361p pd=2.28u as=0.361p ps=2.28u w=1.9u l=0.16u
X1548 a_n3162_51# CMFBin.t17 VSS.t204 VSS.t205 sg13_lv_nmos ad=0.6327p pd=3.71u as=0.6327p ps=3.71u w=3.33u l=0.2u
X1549 VDD.t100 a_n10106_3341# Von.t52 VDD.t1 sg13_lv_pmos ad=0.2603p pd=1.75u as=0.2603p ps=1.75u w=1.37u l=0.35u
X1550 a_n14155_n5285# Von.t157 a_n14528_n9920# VSS.t303 sg13_lv_nmos ad=1.9p pd=10.38u as=1.9p ps=10.38u w=10u l=0.5u
X1551 a_n3381_1772# a_n10013_2465# VDD.t35 VDD.t1 sg13_lv_pmos ad=1.33p pd=7.38u as=1.33p ps=7.38u w=7u l=0.7u
X1552 VDD.t974 a_n6543_n10895# a_n2002_n4396# VDD.t0 sg13_lv_pmos ad=0.19p pd=1.38u as=0.19p ps=1.38u w=1u l=0.7u
X1553 a_n10106_3341# a_n8929_2739# a_n1828_1772# VSS.t322 sg13_lv_nmos ad=0.361p pd=2.28u as=0.646p ps=4.48u w=1.9u l=0.16u
X1554 a_n3162_51# CMFBin.t10 VSS.t225 VSS.t226 sg13_lv_nmos ad=0.6327p pd=3.71u as=0.6327p ps=3.71u w=3.33u l=0.2u
X1555 a_286_1773# VNin.t0 a_n3162_51# VSS.t144 sg13_lv_nmos ad=0.209p pd=1.48u as=0.209p ps=1.48u w=1.1u l=0.15u
X1556 VDD.t709 a_n6543_n10895# a_n5006_n3441# VDD.t0 sg13_lv_pmos ad=0.19p pd=1.38u as=0.19p ps=1.38u w=1u l=0.7u
X1557 a_n3162_51# VNin.t0 a_286_1773# VSS.t145 sg13_lv_nmos ad=0.209p pd=1.48u as=0.209p ps=1.48u w=1.1u l=0.15u
X1558 Vop.t124 a_1220_1772# VDD.t397 VDD.t1 sg13_lv_pmos ad=0.2603p pd=1.75u as=0.4658p ps=3.42u w=1.37u l=0.35u
X1559 a_n5006_n3441# a_n6543_n10895# VDD.t853 VDD.t0 sg13_lv_pmos ad=0.19p pd=1.38u as=0.19p ps=1.38u w=1u l=0.7u
X1560 VDD.t288 a_n10106_3341# Von.t48 VDD.t1 sg13_lv_pmos ad=0.2603p pd=1.75u as=0.2603p ps=1.75u w=1.37u l=0.35u
X1561 Von.t156 VNout.t1 VSS.t321 rppd l=19u w=0.6u
X1562 VSS.t183 CMFBin.t24 a_n3162_51# VSS.t182 sg13_lv_nmos ad=0.6327p pd=3.71u as=0.6327p ps=3.71u w=3.33u l=0.2u
X1563 VSS.t234 CMFBin.t7 a_n3162_51# VSS.t233 sg13_lv_nmos ad=0.6327p pd=3.71u as=0.6327p ps=3.71u w=3.33u l=0.2u
R0 IB.n0 IB.t0 40.8516
R1 IB.n0 IB.t1 3.84284
R2 IB IB.t2 3.79776
R3 IB IB.n0 0.0269
R4 VOUTP.n241 VOUTP.t19 17.0005
R5 VOUTP.n63 VOUTP.t19 17.0005
R6 VOUTP.n244 VOUTP.t14 17.0005
R7 VOUTP.t12 VOUTP.n242 17.0005
R8 VOUTP.n211 VOUTP.t18 17.0005
R9 VOUTP.t18 VOUTP.n180 17.0005
R10 VOUTP.t10 VOUTP.n207 17.0005
R11 VOUTP.n210 VOUTP.t13 17.0005
R12 VOUTP.n153 VOUTP.t11 17.0005
R13 VOUTP.t11 VOUTP.n122 17.0005
R14 VOUTP.t21 VOUTP.n149 17.0005
R15 VOUTP.n152 VOUTP.t0 17.0005
R16 VOUTP.n95 VOUTP.t7 17.0005
R17 VOUTP.t7 VOUTP.n64 17.0005
R18 VOUTP.t5 VOUTP.n91 17.0005
R19 VOUTP.n94 VOUTP.t16 17.0005
R20 VOUTP.t26 VOUTP.n274 11.9114
R21 VOUTP.t26 VOUTP.n279 11.9114
R22 VOUTP.n280 VOUTP.t26 11.9114
R23 VOUTP.n279 VOUTP.n268 9.37179
R24 VOUTP.n281 VOUTP.n280 9.37179
R25 VOUTP.n278 VOUTP.n277 9.0005
R26 VOUTP.n276 VOUTP.n275 9.0005
R27 VOUTP.n273 VOUTP.n272 9.0005
R28 VOUTP.n271 VOUTP.n270 9.0005
R29 VOUTP.n41 VOUTP.t19 8.49691
R30 VOUTP.n45 VOUTP.t19 8.49691
R31 VOUTP.n49 VOUTP.t19 8.49691
R32 VOUTP.n51 VOUTP.t19 8.49691
R33 VOUTP.n53 VOUTP.t19 8.49691
R34 VOUTP.n55 VOUTP.t19 8.49691
R35 VOUTP.n59 VOUTP.t19 8.49691
R36 VOUTP.t6 VOUTP.n42 8.49691
R37 VOUTP.t6 VOUTP.n44 8.49691
R38 VOUTP.t6 VOUTP.n46 8.49691
R39 VOUTP.t6 VOUTP.n48 8.49691
R40 VOUTP.t6 VOUTP.n52 8.49691
R41 VOUTP.t6 VOUTP.n56 8.49691
R42 VOUTP.t6 VOUTP.n58 8.49691
R43 VOUTP.t6 VOUTP.n60 8.49691
R44 VOUTP.t6 VOUTP.n62 8.49691
R45 VOUTP.n14 VOUTP.t14 8.49691
R46 VOUTP.n18 VOUTP.t14 8.49691
R47 VOUTP.n22 VOUTP.t14 8.49691
R48 VOUTP.n24 VOUTP.t14 8.49691
R49 VOUTP.n26 VOUTP.t14 8.49691
R50 VOUTP.n28 VOUTP.t14 8.49691
R51 VOUTP.n32 VOUTP.t14 8.49691
R52 VOUTP.n36 VOUTP.t14 8.49691
R53 VOUTP.n38 VOUTP.t14 8.49691
R54 VOUTP.n40 VOUTP.t14 8.49691
R55 VOUTP.t12 VOUTP.n15 8.49691
R56 VOUTP.t12 VOUTP.n17 8.49691
R57 VOUTP.t12 VOUTP.n19 8.49691
R58 VOUTP.t12 VOUTP.n21 8.49691
R59 VOUTP.t12 VOUTP.n25 8.49691
R60 VOUTP.t12 VOUTP.n29 8.49691
R61 VOUTP.t12 VOUTP.n31 8.49691
R62 VOUTP.t12 VOUTP.n33 8.49691
R63 VOUTP.t12 VOUTP.n35 8.49691
R64 VOUTP.t12 VOUTP.n39 8.49691
R65 VOUTP.n213 VOUTP.t18 8.49691
R66 VOUTP.n217 VOUTP.t18 8.49691
R67 VOUTP.n221 VOUTP.t18 8.49691
R68 VOUTP.n223 VOUTP.t18 8.49691
R69 VOUTP.n225 VOUTP.t18 8.49691
R70 VOUTP.n227 VOUTP.t18 8.49691
R71 VOUTP.n231 VOUTP.t18 8.49691
R72 VOUTP.t17 VOUTP.n214 8.49691
R73 VOUTP.t17 VOUTP.n216 8.49691
R74 VOUTP.t17 VOUTP.n218 8.49691
R75 VOUTP.t17 VOUTP.n220 8.49691
R76 VOUTP.t17 VOUTP.n224 8.49691
R77 VOUTP.t17 VOUTP.n228 8.49691
R78 VOUTP.t17 VOUTP.n230 8.49691
R79 VOUTP.t17 VOUTP.n232 8.49691
R80 VOUTP.t17 VOUTP.n234 8.49691
R81 VOUTP.t10 VOUTP.n195 8.49691
R82 VOUTP.t10 VOUTP.n197 8.49691
R83 VOUTP.t10 VOUTP.n199 8.49691
R84 VOUTP.t10 VOUTP.n200 8.49691
R85 VOUTP.t10 VOUTP.n201 8.49691
R86 VOUTP.t10 VOUTP.n202 8.49691
R87 VOUTP.t10 VOUTP.n204 8.49691
R88 VOUTP.t10 VOUTP.n206 8.49691
R89 VOUTP.n208 VOUTP.t10 8.49691
R90 VOUTP.t10 VOUTP.n181 8.49691
R91 VOUTP.t13 VOUTP.n183 8.49691
R92 VOUTP.t13 VOUTP.n184 8.49691
R93 VOUTP.t13 VOUTP.n185 8.49691
R94 VOUTP.t13 VOUTP.n186 8.49691
R95 VOUTP.t13 VOUTP.n188 8.49691
R96 VOUTP.t13 VOUTP.n190 8.49691
R97 VOUTP.t13 VOUTP.n191 8.49691
R98 VOUTP.t13 VOUTP.n192 8.49691
R99 VOUTP.t13 VOUTP.n193 8.49691
R100 VOUTP.t13 VOUTP.n209 8.49691
R101 VOUTP.n155 VOUTP.t11 8.49691
R102 VOUTP.n159 VOUTP.t11 8.49691
R103 VOUTP.n163 VOUTP.t11 8.49691
R104 VOUTP.n165 VOUTP.t11 8.49691
R105 VOUTP.n167 VOUTP.t11 8.49691
R106 VOUTP.n169 VOUTP.t11 8.49691
R107 VOUTP.n173 VOUTP.t11 8.49691
R108 VOUTP.t9 VOUTP.n156 8.49691
R109 VOUTP.t9 VOUTP.n158 8.49691
R110 VOUTP.t9 VOUTP.n160 8.49691
R111 VOUTP.t9 VOUTP.n162 8.49691
R112 VOUTP.t9 VOUTP.n166 8.49691
R113 VOUTP.t9 VOUTP.n170 8.49691
R114 VOUTP.t9 VOUTP.n172 8.49691
R115 VOUTP.t9 VOUTP.n174 8.49691
R116 VOUTP.t9 VOUTP.n176 8.49691
R117 VOUTP.t21 VOUTP.n137 8.49691
R118 VOUTP.t21 VOUTP.n139 8.49691
R119 VOUTP.t21 VOUTP.n141 8.49691
R120 VOUTP.t21 VOUTP.n142 8.49691
R121 VOUTP.t21 VOUTP.n143 8.49691
R122 VOUTP.t21 VOUTP.n144 8.49691
R123 VOUTP.t21 VOUTP.n146 8.49691
R124 VOUTP.t21 VOUTP.n148 8.49691
R125 VOUTP.n150 VOUTP.t21 8.49691
R126 VOUTP.t21 VOUTP.n123 8.49691
R127 VOUTP.t0 VOUTP.n125 8.49691
R128 VOUTP.t0 VOUTP.n126 8.49691
R129 VOUTP.t0 VOUTP.n127 8.49691
R130 VOUTP.t0 VOUTP.n128 8.49691
R131 VOUTP.t0 VOUTP.n130 8.49691
R132 VOUTP.t0 VOUTP.n132 8.49691
R133 VOUTP.t0 VOUTP.n133 8.49691
R134 VOUTP.t0 VOUTP.n134 8.49691
R135 VOUTP.t0 VOUTP.n135 8.49691
R136 VOUTP.t0 VOUTP.n151 8.49691
R137 VOUTP.n97 VOUTP.t7 8.49691
R138 VOUTP.n101 VOUTP.t7 8.49691
R139 VOUTP.n105 VOUTP.t7 8.49691
R140 VOUTP.n107 VOUTP.t7 8.49691
R141 VOUTP.n109 VOUTP.t7 8.49691
R142 VOUTP.n111 VOUTP.t7 8.49691
R143 VOUTP.n115 VOUTP.t7 8.49691
R144 VOUTP.t4 VOUTP.n98 8.49691
R145 VOUTP.t4 VOUTP.n100 8.49691
R146 VOUTP.t4 VOUTP.n102 8.49691
R147 VOUTP.t4 VOUTP.n104 8.49691
R148 VOUTP.t4 VOUTP.n108 8.49691
R149 VOUTP.t4 VOUTP.n112 8.49691
R150 VOUTP.t4 VOUTP.n114 8.49691
R151 VOUTP.t4 VOUTP.n116 8.49691
R152 VOUTP.t4 VOUTP.n118 8.49691
R153 VOUTP.t5 VOUTP.n79 8.49691
R154 VOUTP.t5 VOUTP.n81 8.49691
R155 VOUTP.t5 VOUTP.n83 8.49691
R156 VOUTP.t5 VOUTP.n84 8.49691
R157 VOUTP.t5 VOUTP.n85 8.49691
R158 VOUTP.t5 VOUTP.n86 8.49691
R159 VOUTP.t5 VOUTP.n88 8.49691
R160 VOUTP.t5 VOUTP.n90 8.49691
R161 VOUTP.n92 VOUTP.t5 8.49691
R162 VOUTP.t5 VOUTP.n65 8.49691
R163 VOUTP.t16 VOUTP.n67 8.49691
R164 VOUTP.t16 VOUTP.n68 8.49691
R165 VOUTP.t16 VOUTP.n69 8.49691
R166 VOUTP.t16 VOUTP.n70 8.49691
R167 VOUTP.t16 VOUTP.n72 8.49691
R168 VOUTP.t16 VOUTP.n74 8.49691
R169 VOUTP.t16 VOUTP.n75 8.49691
R170 VOUTP.t16 VOUTP.n76 8.49691
R171 VOUTP.t16 VOUTP.n77 8.49691
R172 VOUTP.t16 VOUTP.n93 8.49691
R173 VOUTP.n43 VOUTP.t19 8.49685
R174 VOUTP.n47 VOUTP.t19 8.49685
R175 VOUTP.n57 VOUTP.t19 8.49685
R176 VOUTP.n61 VOUTP.t19 8.49685
R177 VOUTP.n240 VOUTP.t6 8.49685
R178 VOUTP.t6 VOUTP.n50 8.49685
R179 VOUTP.t6 VOUTP.n54 8.49685
R180 VOUTP.n16 VOUTP.t14 8.49685
R181 VOUTP.n20 VOUTP.t14 8.49685
R182 VOUTP.n30 VOUTP.t14 8.49685
R183 VOUTP.n34 VOUTP.t14 8.49685
R184 VOUTP.n243 VOUTP.t12 8.49685
R185 VOUTP.t12 VOUTP.n23 8.49685
R186 VOUTP.t12 VOUTP.n27 8.49685
R187 VOUTP.t12 VOUTP.n37 8.49685
R188 VOUTP.n215 VOUTP.t18 8.49685
R189 VOUTP.n219 VOUTP.t18 8.49685
R190 VOUTP.n229 VOUTP.t18 8.49685
R191 VOUTP.n233 VOUTP.t18 8.49685
R192 VOUTP.t17 VOUTP.n212 8.49685
R193 VOUTP.t17 VOUTP.n222 8.49685
R194 VOUTP.t17 VOUTP.n226 8.49685
R195 VOUTP.t10 VOUTP.n196 8.49685
R196 VOUTP.t10 VOUTP.n198 8.49685
R197 VOUTP.t10 VOUTP.n203 8.49685
R198 VOUTP.t10 VOUTP.n205 8.49685
R199 VOUTP.t13 VOUTP.n182 8.49685
R200 VOUTP.t13 VOUTP.n187 8.49685
R201 VOUTP.t13 VOUTP.n189 8.49685
R202 VOUTP.t13 VOUTP.n194 8.49685
R203 VOUTP.n157 VOUTP.t11 8.49685
R204 VOUTP.n161 VOUTP.t11 8.49685
R205 VOUTP.n171 VOUTP.t11 8.49685
R206 VOUTP.n175 VOUTP.t11 8.49685
R207 VOUTP.t9 VOUTP.n154 8.49685
R208 VOUTP.t9 VOUTP.n164 8.49685
R209 VOUTP.t9 VOUTP.n168 8.49685
R210 VOUTP.t21 VOUTP.n138 8.49685
R211 VOUTP.t21 VOUTP.n140 8.49685
R212 VOUTP.t21 VOUTP.n145 8.49685
R213 VOUTP.t21 VOUTP.n147 8.49685
R214 VOUTP.t0 VOUTP.n124 8.49685
R215 VOUTP.t0 VOUTP.n129 8.49685
R216 VOUTP.t0 VOUTP.n131 8.49685
R217 VOUTP.t0 VOUTP.n136 8.49685
R218 VOUTP.n99 VOUTP.t7 8.49685
R219 VOUTP.n103 VOUTP.t7 8.49685
R220 VOUTP.n113 VOUTP.t7 8.49685
R221 VOUTP.n117 VOUTP.t7 8.49685
R222 VOUTP.t4 VOUTP.n96 8.49685
R223 VOUTP.t4 VOUTP.n106 8.49685
R224 VOUTP.t4 VOUTP.n110 8.49685
R225 VOUTP.t5 VOUTP.n80 8.49685
R226 VOUTP.t5 VOUTP.n82 8.49685
R227 VOUTP.t5 VOUTP.n87 8.49685
R228 VOUTP.t5 VOUTP.n89 8.49685
R229 VOUTP.t16 VOUTP.n66 8.49685
R230 VOUTP.t16 VOUTP.n71 8.49685
R231 VOUTP.t16 VOUTP.n73 8.49685
R232 VOUTP.t16 VOUTP.n78 8.49685
R233 VOUTP.n283 VOUTP.t25 6.76476
R234 VOUTP.n282 VOUTP.n281 4.40624
R235 VOUTP.n282 VOUTP.n269 4.40624
R236 VOUTP.n282 VOUTP.n268 4.40624
R237 VOUTP.t6 VOUTP.n239 3.4022
R238 VOUTP.n235 VOUTP.t17 3.4022
R239 VOUTP.n177 VOUTP.t9 3.4022
R240 VOUTP.n119 VOUTP.t4 3.4022
R241 VOUTP.n239 VOUTP.t19 3.40192
R242 VOUTP.n235 VOUTP.t18 3.40192
R243 VOUTP.n177 VOUTP.t11 3.40192
R244 VOUTP.n119 VOUTP.t7 3.40192
R245 VOUTP.n284 VOUTP.n283 1.59999
R246 VOUTP.n262 VOUTP.n1 1.13911
R247 VOUTP.n267 VOUTP.n2 1.13264
R248 VOUTP.n4 VOUTP.n3 1.1255
R249 VOUTP.n266 VOUTP.n265 1.1255
R250 VOUTP.n261 VOUTP.n260 0.729408
R251 VOUTP VOUTP.n284 0.672953
R252 VOUTP.n257 VOUTP.n256 0.604502
R253 VOUTP.n253 VOUTP.n252 0.604502
R254 VOUTP.n252 VOUTP.n5 0.603833
R255 VOUTP.n251 VOUTP.n250 0.6005
R256 VOUTP.n249 VOUTP.n6 0.6005
R257 VOUTP.n258 VOUTP.n257 0.6005
R258 VOUTP.n254 VOUTP.n251 0.6005
R259 VOUTP.n255 VOUTP.n249 0.6005
R260 VOUTP.n11 VOUTP.t2 0.592113
R261 VOUTP.n9 VOUTP.t8 0.592113
R262 VOUTP.n7 VOUTP.t22 0.592113
R263 VOUTP.n13 VOUTP.t1 0.592113
R264 VOUTP.n13 VOUTP.t20 0.59207
R265 VOUTP.n11 VOUTP.t3 0.59207
R266 VOUTP.n9 VOUTP.t24 0.59207
R267 VOUTP.n7 VOUTP.t23 0.59207
R268 VOUTP.n264 VOUTP.n263 0.560516
R269 VOUTP.n263 VOUTP.n262 0.560516
R270 VOUTP.n284 VOUTP.n267 0.560178
R271 VOUTP.n284 VOUTP.n1 0.560178
R272 VOUTP.n261 VOUTP.t15 0.521198
R273 VOUTP.n283 VOUTP.n282 0.444909
R274 VOUTP.n238 VOUTP.n237 0.4105
R275 VOUTP.n277 VOUTP.n276 0.3877
R276 VOUTP.n272 VOUTP.n270 0.3877
R277 VOUTP.n278 VOUTP.n275 0.369262
R278 VOUTP.n273 VOUTP.n271 0.369262
R279 VOUTP.n253 VOUTP.n0 0.304502
R280 VOUTP.n256 VOUTP.n0 0.304502
R281 VOUTP.n260 VOUTP.n259 0.299584
R282 VOUTP.n260 VOUTP.n5 0.299584
R283 VOUTP.n121 VOUTP.n120 0.27491
R284 VOUTP.n179 VOUTP.n178 0.27491
R285 VOUTP.n237 VOUTP.n236 0.27491
R286 VOUTP VOUTP.n0 0.23299
R287 VOUTP.n246 VOUTP.n245 0.212026
R288 VOUTP.n277 VOUTP.n268 0.190523
R289 VOUTP.n272 VOUTP.n269 0.190523
R290 VOUTP.n281 VOUTP.n270 0.190523
R291 VOUTP.n276 VOUTP.n269 0.190523
R292 VOUTP.n280 VOUTP.n271 0.181769
R293 VOUTP.n279 VOUTP.n278 0.181769
R294 VOUTP.n274 VOUTP.n273 0.181769
R295 VOUTP.n275 VOUTP.n274 0.181769
R296 VOUTP.n245 VOUTP.n13 0.163251
R297 VOUTP.n12 VOUTP.n11 0.163251
R298 VOUTP.n10 VOUTP.n9 0.163251
R299 VOUTP.n8 VOUTP.n7 0.163251
R300 VOUTP.n263 VOUTP.n261 0.151838
R301 VOUTP.n248 VOUTP.n8 0.147515
R302 VOUTP.n247 VOUTP.n10 0.147515
R303 VOUTP.n246 VOUTP.n12 0.147515
R304 VOUTP.n179 VOUTP.n121 0.13733
R305 VOUTP.n237 VOUTP.n179 0.13733
R306 VOUTP.n121 VOUTP.n2 0.120915
R307 VOUTP.n248 VOUTP.n247 0.067002
R308 VOUTP.n247 VOUTP.n246 0.067002
R309 VOUTP.n258 VOUTP.n248 0.0584195
R310 VOUTP.n239 VOUTP.n238 0.0333092
R311 VOUTP.n236 VOUTP.n235 0.0333092
R312 VOUTP.n178 VOUTP.n177 0.0333092
R313 VOUTP.n120 VOUTP.n119 0.0333092
R314 VOUTP.n242 VOUTP.n241 0.0317931
R315 VOUTP.n211 VOUTP.n210 0.0317931
R316 VOUTP.n153 VOUTP.n152 0.0317931
R317 VOUTP.n95 VOUTP.n94 0.0317931
R318 VOUTP.n243 VOUTP.n14 0.0179683
R319 VOUTP.n16 VOUTP.n15 0.0179683
R320 VOUTP.n20 VOUTP.n19 0.0179683
R321 VOUTP.n24 VOUTP.n23 0.0179683
R322 VOUTP.n28 VOUTP.n27 0.0179683
R323 VOUTP.n30 VOUTP.n29 0.0179683
R324 VOUTP.n34 VOUTP.n33 0.0179683
R325 VOUTP.n38 VOUTP.n37 0.0179683
R326 VOUTP.n240 VOUTP.n41 0.0179683
R327 VOUTP.n43 VOUTP.n42 0.0179683
R328 VOUTP.n47 VOUTP.n46 0.0179683
R329 VOUTP.n51 VOUTP.n50 0.0179683
R330 VOUTP.n55 VOUTP.n54 0.0179683
R331 VOUTP.n57 VOUTP.n56 0.0179683
R332 VOUTP.n61 VOUTP.n60 0.0179683
R333 VOUTP.n44 VOUTP.n43 0.0179683
R334 VOUTP.n48 VOUTP.n47 0.0179683
R335 VOUTP.n50 VOUTP.n49 0.0179683
R336 VOUTP.n54 VOUTP.n53 0.0179683
R337 VOUTP.n58 VOUTP.n57 0.0179683
R338 VOUTP.n62 VOUTP.n61 0.0179683
R339 VOUTP.n17 VOUTP.n16 0.0179683
R340 VOUTP.n21 VOUTP.n20 0.0179683
R341 VOUTP.n23 VOUTP.n22 0.0179683
R342 VOUTP.n27 VOUTP.n26 0.0179683
R343 VOUTP.n31 VOUTP.n30 0.0179683
R344 VOUTP.n35 VOUTP.n34 0.0179683
R345 VOUTP.n37 VOUTP.n36 0.0179683
R346 VOUTP.n195 VOUTP.n182 0.0179683
R347 VOUTP.n196 VOUTP.n183 0.0179683
R348 VOUTP.n198 VOUTP.n185 0.0179683
R349 VOUTP.n200 VOUTP.n187 0.0179683
R350 VOUTP.n202 VOUTP.n189 0.0179683
R351 VOUTP.n203 VOUTP.n190 0.0179683
R352 VOUTP.n205 VOUTP.n192 0.0179683
R353 VOUTP.n208 VOUTP.n194 0.0179683
R354 VOUTP.n213 VOUTP.n212 0.0179683
R355 VOUTP.n215 VOUTP.n214 0.0179683
R356 VOUTP.n219 VOUTP.n218 0.0179683
R357 VOUTP.n223 VOUTP.n222 0.0179683
R358 VOUTP.n227 VOUTP.n226 0.0179683
R359 VOUTP.n229 VOUTP.n228 0.0179683
R360 VOUTP.n233 VOUTP.n232 0.0179683
R361 VOUTP.n216 VOUTP.n215 0.0179683
R362 VOUTP.n220 VOUTP.n219 0.0179683
R363 VOUTP.n222 VOUTP.n221 0.0179683
R364 VOUTP.n226 VOUTP.n225 0.0179683
R365 VOUTP.n230 VOUTP.n229 0.0179683
R366 VOUTP.n234 VOUTP.n233 0.0179683
R367 VOUTP.n196 VOUTP.n184 0.0179683
R368 VOUTP.n198 VOUTP.n186 0.0179683
R369 VOUTP.n199 VOUTP.n187 0.0179683
R370 VOUTP.n201 VOUTP.n189 0.0179683
R371 VOUTP.n203 VOUTP.n191 0.0179683
R372 VOUTP.n205 VOUTP.n193 0.0179683
R373 VOUTP.n206 VOUTP.n194 0.0179683
R374 VOUTP.n137 VOUTP.n124 0.0179683
R375 VOUTP.n138 VOUTP.n125 0.0179683
R376 VOUTP.n140 VOUTP.n127 0.0179683
R377 VOUTP.n142 VOUTP.n129 0.0179683
R378 VOUTP.n144 VOUTP.n131 0.0179683
R379 VOUTP.n145 VOUTP.n132 0.0179683
R380 VOUTP.n147 VOUTP.n134 0.0179683
R381 VOUTP.n150 VOUTP.n136 0.0179683
R382 VOUTP.n155 VOUTP.n154 0.0179683
R383 VOUTP.n157 VOUTP.n156 0.0179683
R384 VOUTP.n161 VOUTP.n160 0.0179683
R385 VOUTP.n165 VOUTP.n164 0.0179683
R386 VOUTP.n169 VOUTP.n168 0.0179683
R387 VOUTP.n171 VOUTP.n170 0.0179683
R388 VOUTP.n175 VOUTP.n174 0.0179683
R389 VOUTP.n158 VOUTP.n157 0.0179683
R390 VOUTP.n162 VOUTP.n161 0.0179683
R391 VOUTP.n164 VOUTP.n163 0.0179683
R392 VOUTP.n168 VOUTP.n167 0.0179683
R393 VOUTP.n172 VOUTP.n171 0.0179683
R394 VOUTP.n176 VOUTP.n175 0.0179683
R395 VOUTP.n138 VOUTP.n126 0.0179683
R396 VOUTP.n140 VOUTP.n128 0.0179683
R397 VOUTP.n141 VOUTP.n129 0.0179683
R398 VOUTP.n143 VOUTP.n131 0.0179683
R399 VOUTP.n145 VOUTP.n133 0.0179683
R400 VOUTP.n147 VOUTP.n135 0.0179683
R401 VOUTP.n148 VOUTP.n136 0.0179683
R402 VOUTP.n79 VOUTP.n66 0.0179683
R403 VOUTP.n80 VOUTP.n67 0.0179683
R404 VOUTP.n82 VOUTP.n69 0.0179683
R405 VOUTP.n84 VOUTP.n71 0.0179683
R406 VOUTP.n86 VOUTP.n73 0.0179683
R407 VOUTP.n87 VOUTP.n74 0.0179683
R408 VOUTP.n89 VOUTP.n76 0.0179683
R409 VOUTP.n92 VOUTP.n78 0.0179683
R410 VOUTP.n97 VOUTP.n96 0.0179683
R411 VOUTP.n99 VOUTP.n98 0.0179683
R412 VOUTP.n103 VOUTP.n102 0.0179683
R413 VOUTP.n107 VOUTP.n106 0.0179683
R414 VOUTP.n111 VOUTP.n110 0.0179683
R415 VOUTP.n113 VOUTP.n112 0.0179683
R416 VOUTP.n117 VOUTP.n116 0.0179683
R417 VOUTP.n100 VOUTP.n99 0.0179683
R418 VOUTP.n104 VOUTP.n103 0.0179683
R419 VOUTP.n106 VOUTP.n105 0.0179683
R420 VOUTP.n110 VOUTP.n109 0.0179683
R421 VOUTP.n114 VOUTP.n113 0.0179683
R422 VOUTP.n118 VOUTP.n117 0.0179683
R423 VOUTP.n80 VOUTP.n68 0.0179683
R424 VOUTP.n82 VOUTP.n70 0.0179683
R425 VOUTP.n83 VOUTP.n71 0.0179683
R426 VOUTP.n85 VOUTP.n73 0.0179683
R427 VOUTP.n87 VOUTP.n75 0.0179683
R428 VOUTP.n89 VOUTP.n77 0.0179683
R429 VOUTP.n90 VOUTP.n78 0.0179683
R430 VOUTP.n18 VOUTP.n17 0.0178499
R431 VOUTP.n22 VOUTP.n21 0.0178499
R432 VOUTP.n26 VOUTP.n25 0.0178499
R433 VOUTP.n32 VOUTP.n31 0.0178499
R434 VOUTP.n36 VOUTP.n35 0.0178499
R435 VOUTP.n40 VOUTP.n39 0.0178499
R436 VOUTP.n45 VOUTP.n44 0.0178499
R437 VOUTP.n49 VOUTP.n48 0.0178499
R438 VOUTP.n53 VOUTP.n52 0.0178499
R439 VOUTP.n59 VOUTP.n58 0.0178499
R440 VOUTP.n42 VOUTP.n41 0.0178499
R441 VOUTP.n46 VOUTP.n45 0.0178499
R442 VOUTP.n52 VOUTP.n51 0.0178499
R443 VOUTP.n56 VOUTP.n55 0.0178499
R444 VOUTP.n60 VOUTP.n59 0.0178499
R445 VOUTP.n15 VOUTP.n14 0.0178499
R446 VOUTP.n19 VOUTP.n18 0.0178499
R447 VOUTP.n25 VOUTP.n24 0.0178499
R448 VOUTP.n29 VOUTP.n28 0.0178499
R449 VOUTP.n33 VOUTP.n32 0.0178499
R450 VOUTP.n39 VOUTP.n38 0.0178499
R451 VOUTP.n197 VOUTP.n184 0.0178499
R452 VOUTP.n199 VOUTP.n186 0.0178499
R453 VOUTP.n201 VOUTP.n188 0.0178499
R454 VOUTP.n204 VOUTP.n191 0.0178499
R455 VOUTP.n206 VOUTP.n193 0.0178499
R456 VOUTP.n209 VOUTP.n181 0.0178499
R457 VOUTP.n217 VOUTP.n216 0.0178499
R458 VOUTP.n221 VOUTP.n220 0.0178499
R459 VOUTP.n225 VOUTP.n224 0.0178499
R460 VOUTP.n231 VOUTP.n230 0.0178499
R461 VOUTP.n214 VOUTP.n213 0.0178499
R462 VOUTP.n218 VOUTP.n217 0.0178499
R463 VOUTP.n224 VOUTP.n223 0.0178499
R464 VOUTP.n228 VOUTP.n227 0.0178499
R465 VOUTP.n232 VOUTP.n231 0.0178499
R466 VOUTP.n195 VOUTP.n183 0.0178499
R467 VOUTP.n197 VOUTP.n185 0.0178499
R468 VOUTP.n200 VOUTP.n188 0.0178499
R469 VOUTP.n202 VOUTP.n190 0.0178499
R470 VOUTP.n204 VOUTP.n192 0.0178499
R471 VOUTP.n209 VOUTP.n208 0.0178499
R472 VOUTP.n139 VOUTP.n126 0.0178499
R473 VOUTP.n141 VOUTP.n128 0.0178499
R474 VOUTP.n143 VOUTP.n130 0.0178499
R475 VOUTP.n146 VOUTP.n133 0.0178499
R476 VOUTP.n148 VOUTP.n135 0.0178499
R477 VOUTP.n151 VOUTP.n123 0.0178499
R478 VOUTP.n159 VOUTP.n158 0.0178499
R479 VOUTP.n163 VOUTP.n162 0.0178499
R480 VOUTP.n167 VOUTP.n166 0.0178499
R481 VOUTP.n173 VOUTP.n172 0.0178499
R482 VOUTP.n156 VOUTP.n155 0.0178499
R483 VOUTP.n160 VOUTP.n159 0.0178499
R484 VOUTP.n166 VOUTP.n165 0.0178499
R485 VOUTP.n170 VOUTP.n169 0.0178499
R486 VOUTP.n174 VOUTP.n173 0.0178499
R487 VOUTP.n137 VOUTP.n125 0.0178499
R488 VOUTP.n139 VOUTP.n127 0.0178499
R489 VOUTP.n142 VOUTP.n130 0.0178499
R490 VOUTP.n144 VOUTP.n132 0.0178499
R491 VOUTP.n146 VOUTP.n134 0.0178499
R492 VOUTP.n151 VOUTP.n150 0.0178499
R493 VOUTP.n81 VOUTP.n68 0.0178499
R494 VOUTP.n83 VOUTP.n70 0.0178499
R495 VOUTP.n85 VOUTP.n72 0.0178499
R496 VOUTP.n88 VOUTP.n75 0.0178499
R497 VOUTP.n90 VOUTP.n77 0.0178499
R498 VOUTP.n93 VOUTP.n65 0.0178499
R499 VOUTP.n101 VOUTP.n100 0.0178499
R500 VOUTP.n105 VOUTP.n104 0.0178499
R501 VOUTP.n109 VOUTP.n108 0.0178499
R502 VOUTP.n115 VOUTP.n114 0.0178499
R503 VOUTP.n98 VOUTP.n97 0.0178499
R504 VOUTP.n102 VOUTP.n101 0.0178499
R505 VOUTP.n108 VOUTP.n107 0.0178499
R506 VOUTP.n112 VOUTP.n111 0.0178499
R507 VOUTP.n116 VOUTP.n115 0.0178499
R508 VOUTP.n79 VOUTP.n67 0.0178499
R509 VOUTP.n81 VOUTP.n69 0.0178499
R510 VOUTP.n84 VOUTP.n72 0.0178499
R511 VOUTP.n86 VOUTP.n74 0.0178499
R512 VOUTP.n88 VOUTP.n76 0.0178499
R513 VOUTP.n93 VOUTP.n92 0.0178499
R514 VOUTP.n245 VOUTP.n244 0.0161466
R515 VOUTP.n207 VOUTP.n12 0.0161466
R516 VOUTP.n149 VOUTP.n10 0.0161466
R517 VOUTP.n91 VOUTP.n8 0.0161466
R518 VOUTP.n266 VOUTP.n3 0.0138671
R519 VOUTP.n265 VOUTP.n4 0.0125
R520 VOUTP.n241 VOUTP.n240 0.00929337
R521 VOUTP.n244 VOUTP.n243 0.00929337
R522 VOUTP.n212 VOUTP.n211 0.00929337
R523 VOUTP.n207 VOUTP.n182 0.00929337
R524 VOUTP.n154 VOUTP.n153 0.00929337
R525 VOUTP.n149 VOUTP.n124 0.00929337
R526 VOUTP.n96 VOUTP.n95 0.00929337
R527 VOUTP.n91 VOUTP.n66 0.00929337
R528 VOUTP.n63 VOUTP.n62 0.00917495
R529 VOUTP.n242 VOUTP.n40 0.00917495
R530 VOUTP.n234 VOUTP.n180 0.00917495
R531 VOUTP.n210 VOUTP.n181 0.00917495
R532 VOUTP.n176 VOUTP.n122 0.00917495
R533 VOUTP.n152 VOUTP.n123 0.00917495
R534 VOUTP.n118 VOUTP.n64 0.00917495
R535 VOUTP.n94 VOUTP.n65 0.00917495
R536 VOUTP.n3 VOUTP.n1 0.00764407
R537 VOUTP.n267 VOUTP.n266 0.00764407
R538 VOUTP.n252 VOUTP.n251 0.00750498
R539 VOUTP.n251 VOUTP.n249 0.00750498
R540 VOUTP.n257 VOUTP.n249 0.00750498
R541 VOUTP.n255 VOUTP.n254 0.00750498
R542 VOUTP.n262 VOUTP.n4 0.00696817
R543 VOUTP.n264 VOUTP.n2 0.00696817
R544 VOUTP.n265 VOUTP.n264 0.00696817
R545 VOUTP.n250 VOUTP.n6 0.00619272
R546 VOUTP.n238 VOUTP.n63 0.00618966
R547 VOUTP.n236 VOUTP.n180 0.00618966
R548 VOUTP.n178 VOUTP.n122 0.00618966
R549 VOUTP.n120 VOUTP.n64 0.00618966
R550 VOUTP.n254 VOUTP.n253 0.00446207
R551 VOUTP.n256 VOUTP.n255 0.00446207
R552 VOUTP.n259 VOUTP.n6 0.00383292
R553 VOUTP.n259 VOUTP.n258 0.00383292
R554 VOUTP.n250 VOUTP.n5 0.00383292
R555 CMFBout CMFBout.n34 62.1665
R556 CMFBout.n33 CMFBout.t30 15.0005
R557 CMFBout.t30 CMFBout.n5 15.0005
R558 CMFBout.n18 CMFBout.t16 6.63982
R559 CMFBout.n8 CMFBout.t3 6.63939
R560 CMFBout.n9 CMFBout.t2 6.63939
R561 CMFBout.n10 CMFBout.t1 6.63939
R562 CMFBout.n11 CMFBout.t0 6.63939
R563 CMFBout.n12 CMFBout.t22 6.63939
R564 CMFBout.n13 CMFBout.t21 6.63939
R565 CMFBout.n14 CMFBout.t20 6.63939
R566 CMFBout.n15 CMFBout.t19 6.63939
R567 CMFBout.n16 CMFBout.t18 6.63939
R568 CMFBout.n17 CMFBout.t17 6.63939
R569 CMFBout.n1 CMFBout.t7 6.63939
R570 CMFBout.n0 CMFBout.t6 6.63939
R571 CMFBout.n6 CMFBout.t5 6.63939
R572 CMFBout.n7 CMFBout.t4 6.63939
R573 CMFBout.n8 CMFBout.t11 5.52048
R574 CMFBout.n9 CMFBout.t10 5.52048
R575 CMFBout.n10 CMFBout.t9 5.52048
R576 CMFBout.n11 CMFBout.t8 5.52048
R577 CMFBout.n12 CMFBout.t29 5.52048
R578 CMFBout.n13 CMFBout.t28 5.52048
R579 CMFBout.n14 CMFBout.t27 5.52048
R580 CMFBout.n15 CMFBout.t26 5.52048
R581 CMFBout.n16 CMFBout.t25 5.52048
R582 CMFBout.n17 CMFBout.t24 5.52048
R583 CMFBout.n18 CMFBout.t23 5.52048
R584 CMFBout.n1 CMFBout.t15 5.52048
R585 CMFBout.n0 CMFBout.t14 5.52048
R586 CMFBout.n6 CMFBout.t13 5.52048
R587 CMFBout.n7 CMFBout.t12 5.52048
R588 CMFBout.n34 CMFBout.t31 2.72057
R589 CMFBout.n29 CMFBout.t38 2.72057
R590 CMFBout.n31 CMFBout.t33 2.72057
R591 CMFBout.n3 CMFBout.t32 2.72057
R592 CMFBout.n2 CMFBout.t36 2.72057
R593 CMFBout.n2 CMFBout.n1 0.76389
R594 CMFBout.n19 CMFBout.n18 0.738409
R595 CMFBout.n28 CMFBout.n8 0.559964
R596 CMFBout.n27 CMFBout.n9 0.559964
R597 CMFBout.n26 CMFBout.n10 0.559964
R598 CMFBout.n25 CMFBout.n11 0.559964
R599 CMFBout.n24 CMFBout.n12 0.559964
R600 CMFBout.n23 CMFBout.n13 0.559964
R601 CMFBout.n22 CMFBout.n14 0.559964
R602 CMFBout.n21 CMFBout.n15 0.559964
R603 CMFBout.n20 CMFBout.n16 0.559964
R604 CMFBout.n19 CMFBout.n17 0.559964
R605 CMFBout.n4 CMFBout.n0 0.559964
R606 CMFBout.n32 CMFBout.n6 0.559964
R607 CMFBout.n30 CMFBout.n7 0.559964
R608 CMFBout.n28 CMFBout.n27 0.178944
R609 CMFBout.n27 CMFBout.n26 0.178944
R610 CMFBout.n26 CMFBout.n25 0.178944
R611 CMFBout.n25 CMFBout.n24 0.178944
R612 CMFBout.n24 CMFBout.n23 0.178944
R613 CMFBout.n23 CMFBout.n22 0.178944
R614 CMFBout.n22 CMFBout.n21 0.178944
R615 CMFBout.n21 CMFBout.n20 0.178944
R616 CMFBout.n20 CMFBout.n19 0.178944
R617 CMFBout.n29 CMFBout.n28 0.112759
R618 CMFBout.n3 CMFBout.n2 0.0864259
R619 CMFBout.n5 CMFBout.n4 0.0701296
R620 CMFBout.n32 CMFBout.n31 0.0605
R621 CMFBout.n31 CMFBout.n30 0.0486481
R622 CMFBout.n30 CMFBout.n29 0.0382778
R623 CMFBout.n33 CMFBout.n32 0.0138333
R624 CMFBout.n34 CMFBout.n5 0.0130926
R625 CMFBout.n34 CMFBout.n33 0.0130926
R626 CMFBout.n4 CMFBout.n3 0.0042037
R627 VREF VREF.t0 11.2846
R628 VOUTN.n209 VOUTN.t0 17.0005
R629 VOUTN.t0 VOUTN.n178 17.0005
R630 VOUTN.t21 VOUTN.n205 17.0005
R631 VOUTN.n208 VOUTN.t20 17.0005
R632 VOUTN.n152 VOUTN.t23 17.0005
R633 VOUTN.t23 VOUTN.n121 17.0005
R634 VOUTN.t18 VOUTN.n148 17.0005
R635 VOUTN.n151 VOUTN.t16 17.0005
R636 VOUTN.n95 VOUTN.t4 17.0005
R637 VOUTN.t4 VOUTN.n64 17.0005
R638 VOUTN.t1 VOUTN.n91 17.0005
R639 VOUTN.n94 VOUTN.t5 17.0005
R640 VOUTN.n241 VOUTN.t24 17.0005
R641 VOUTN.n63 VOUTN.t24 17.0005
R642 VOUTN.n244 VOUTN.t3 17.0005
R643 VOUTN.t19 VOUTN.n242 17.0005
R644 VOUTN.t26 VOUTN.n274 11.9114
R645 VOUTN.t26 VOUTN.n279 11.9114
R646 VOUTN.n280 VOUTN.t26 11.9114
R647 VOUTN.n279 VOUTN.n268 9.37179
R648 VOUTN.n281 VOUTN.n280 9.37179
R649 VOUTN.n278 VOUTN.n277 9.0005
R650 VOUTN.n276 VOUTN.n275 9.0005
R651 VOUTN.n273 VOUTN.n272 9.0005
R652 VOUTN.n271 VOUTN.n270 9.0005
R653 VOUTN.n211 VOUTN.t0 8.49691
R654 VOUTN.n215 VOUTN.t0 8.49691
R655 VOUTN.n219 VOUTN.t0 8.49691
R656 VOUTN.n221 VOUTN.t0 8.49691
R657 VOUTN.n223 VOUTN.t0 8.49691
R658 VOUTN.n225 VOUTN.t0 8.49691
R659 VOUTN.n229 VOUTN.t0 8.49691
R660 VOUTN.t17 VOUTN.n212 8.49691
R661 VOUTN.t17 VOUTN.n214 8.49691
R662 VOUTN.t17 VOUTN.n216 8.49691
R663 VOUTN.t17 VOUTN.n218 8.49691
R664 VOUTN.t17 VOUTN.n222 8.49691
R665 VOUTN.t17 VOUTN.n226 8.49691
R666 VOUTN.t17 VOUTN.n228 8.49691
R667 VOUTN.t17 VOUTN.n230 8.49691
R668 VOUTN.t17 VOUTN.n232 8.49691
R669 VOUTN.t21 VOUTN.n193 8.49691
R670 VOUTN.t21 VOUTN.n195 8.49691
R671 VOUTN.t21 VOUTN.n197 8.49691
R672 VOUTN.t21 VOUTN.n198 8.49691
R673 VOUTN.t21 VOUTN.n199 8.49691
R674 VOUTN.t21 VOUTN.n200 8.49691
R675 VOUTN.t21 VOUTN.n202 8.49691
R676 VOUTN.t21 VOUTN.n204 8.49691
R677 VOUTN.n206 VOUTN.t21 8.49691
R678 VOUTN.t21 VOUTN.n179 8.49691
R679 VOUTN.t20 VOUTN.n181 8.49691
R680 VOUTN.t20 VOUTN.n182 8.49691
R681 VOUTN.t20 VOUTN.n183 8.49691
R682 VOUTN.t20 VOUTN.n184 8.49691
R683 VOUTN.t20 VOUTN.n186 8.49691
R684 VOUTN.t20 VOUTN.n188 8.49691
R685 VOUTN.t20 VOUTN.n189 8.49691
R686 VOUTN.t20 VOUTN.n190 8.49691
R687 VOUTN.t20 VOUTN.n191 8.49691
R688 VOUTN.t20 VOUTN.n207 8.49691
R689 VOUTN.n154 VOUTN.t23 8.49691
R690 VOUTN.n158 VOUTN.t23 8.49691
R691 VOUTN.n162 VOUTN.t23 8.49691
R692 VOUTN.n164 VOUTN.t23 8.49691
R693 VOUTN.n166 VOUTN.t23 8.49691
R694 VOUTN.n168 VOUTN.t23 8.49691
R695 VOUTN.n172 VOUTN.t23 8.49691
R696 VOUTN.t13 VOUTN.n155 8.49691
R697 VOUTN.t13 VOUTN.n157 8.49691
R698 VOUTN.t13 VOUTN.n159 8.49691
R699 VOUTN.t13 VOUTN.n161 8.49691
R700 VOUTN.t13 VOUTN.n165 8.49691
R701 VOUTN.t13 VOUTN.n169 8.49691
R702 VOUTN.t13 VOUTN.n171 8.49691
R703 VOUTN.t13 VOUTN.n173 8.49691
R704 VOUTN.t13 VOUTN.n175 8.49691
R705 VOUTN.t18 VOUTN.n136 8.49691
R706 VOUTN.t18 VOUTN.n138 8.49691
R707 VOUTN.t18 VOUTN.n140 8.49691
R708 VOUTN.t18 VOUTN.n141 8.49691
R709 VOUTN.t18 VOUTN.n142 8.49691
R710 VOUTN.t18 VOUTN.n143 8.49691
R711 VOUTN.t18 VOUTN.n145 8.49691
R712 VOUTN.t18 VOUTN.n147 8.49691
R713 VOUTN.n149 VOUTN.t18 8.49691
R714 VOUTN.t18 VOUTN.n122 8.49691
R715 VOUTN.t16 VOUTN.n124 8.49691
R716 VOUTN.t16 VOUTN.n125 8.49691
R717 VOUTN.t16 VOUTN.n126 8.49691
R718 VOUTN.t16 VOUTN.n127 8.49691
R719 VOUTN.t16 VOUTN.n129 8.49691
R720 VOUTN.t16 VOUTN.n131 8.49691
R721 VOUTN.t16 VOUTN.n132 8.49691
R722 VOUTN.t16 VOUTN.n133 8.49691
R723 VOUTN.t16 VOUTN.n134 8.49691
R724 VOUTN.t16 VOUTN.n150 8.49691
R725 VOUTN.n97 VOUTN.t4 8.49691
R726 VOUTN.n101 VOUTN.t4 8.49691
R727 VOUTN.n105 VOUTN.t4 8.49691
R728 VOUTN.n107 VOUTN.t4 8.49691
R729 VOUTN.n109 VOUTN.t4 8.49691
R730 VOUTN.n111 VOUTN.t4 8.49691
R731 VOUTN.n115 VOUTN.t4 8.49691
R732 VOUTN.t12 VOUTN.n98 8.49691
R733 VOUTN.t12 VOUTN.n100 8.49691
R734 VOUTN.t12 VOUTN.n102 8.49691
R735 VOUTN.t12 VOUTN.n104 8.49691
R736 VOUTN.t12 VOUTN.n108 8.49691
R737 VOUTN.t12 VOUTN.n112 8.49691
R738 VOUTN.t12 VOUTN.n114 8.49691
R739 VOUTN.t12 VOUTN.n116 8.49691
R740 VOUTN.t12 VOUTN.n118 8.49691
R741 VOUTN.t1 VOUTN.n79 8.49691
R742 VOUTN.t1 VOUTN.n81 8.49691
R743 VOUTN.t1 VOUTN.n83 8.49691
R744 VOUTN.t1 VOUTN.n84 8.49691
R745 VOUTN.t1 VOUTN.n85 8.49691
R746 VOUTN.t1 VOUTN.n86 8.49691
R747 VOUTN.t1 VOUTN.n88 8.49691
R748 VOUTN.t1 VOUTN.n90 8.49691
R749 VOUTN.n92 VOUTN.t1 8.49691
R750 VOUTN.t1 VOUTN.n65 8.49691
R751 VOUTN.t5 VOUTN.n67 8.49691
R752 VOUTN.t5 VOUTN.n68 8.49691
R753 VOUTN.t5 VOUTN.n69 8.49691
R754 VOUTN.t5 VOUTN.n70 8.49691
R755 VOUTN.t5 VOUTN.n72 8.49691
R756 VOUTN.t5 VOUTN.n74 8.49691
R757 VOUTN.t5 VOUTN.n75 8.49691
R758 VOUTN.t5 VOUTN.n76 8.49691
R759 VOUTN.t5 VOUTN.n77 8.49691
R760 VOUTN.t5 VOUTN.n93 8.49691
R761 VOUTN.n41 VOUTN.t24 8.49691
R762 VOUTN.n45 VOUTN.t24 8.49691
R763 VOUTN.n49 VOUTN.t24 8.49691
R764 VOUTN.n51 VOUTN.t24 8.49691
R765 VOUTN.n53 VOUTN.t24 8.49691
R766 VOUTN.n55 VOUTN.t24 8.49691
R767 VOUTN.n59 VOUTN.t24 8.49691
R768 VOUTN.t11 VOUTN.n42 8.49691
R769 VOUTN.t11 VOUTN.n44 8.49691
R770 VOUTN.t11 VOUTN.n46 8.49691
R771 VOUTN.t11 VOUTN.n48 8.49691
R772 VOUTN.t11 VOUTN.n52 8.49691
R773 VOUTN.t11 VOUTN.n56 8.49691
R774 VOUTN.t11 VOUTN.n58 8.49691
R775 VOUTN.t11 VOUTN.n60 8.49691
R776 VOUTN.t11 VOUTN.n62 8.49691
R777 VOUTN.n14 VOUTN.t3 8.49691
R778 VOUTN.n18 VOUTN.t3 8.49691
R779 VOUTN.n22 VOUTN.t3 8.49691
R780 VOUTN.n24 VOUTN.t3 8.49691
R781 VOUTN.n26 VOUTN.t3 8.49691
R782 VOUTN.n28 VOUTN.t3 8.49691
R783 VOUTN.n32 VOUTN.t3 8.49691
R784 VOUTN.n36 VOUTN.t3 8.49691
R785 VOUTN.n38 VOUTN.t3 8.49691
R786 VOUTN.n40 VOUTN.t3 8.49691
R787 VOUTN.t19 VOUTN.n15 8.49691
R788 VOUTN.t19 VOUTN.n17 8.49691
R789 VOUTN.t19 VOUTN.n19 8.49691
R790 VOUTN.t19 VOUTN.n21 8.49691
R791 VOUTN.t19 VOUTN.n25 8.49691
R792 VOUTN.t19 VOUTN.n29 8.49691
R793 VOUTN.t19 VOUTN.n31 8.49691
R794 VOUTN.t19 VOUTN.n33 8.49691
R795 VOUTN.t19 VOUTN.n35 8.49691
R796 VOUTN.t19 VOUTN.n39 8.49691
R797 VOUTN.n213 VOUTN.t0 8.49685
R798 VOUTN.n217 VOUTN.t0 8.49685
R799 VOUTN.n227 VOUTN.t0 8.49685
R800 VOUTN.n231 VOUTN.t0 8.49685
R801 VOUTN.t17 VOUTN.n210 8.49685
R802 VOUTN.t17 VOUTN.n220 8.49685
R803 VOUTN.t17 VOUTN.n224 8.49685
R804 VOUTN.t21 VOUTN.n194 8.49685
R805 VOUTN.t21 VOUTN.n196 8.49685
R806 VOUTN.t21 VOUTN.n201 8.49685
R807 VOUTN.t21 VOUTN.n203 8.49685
R808 VOUTN.t20 VOUTN.n180 8.49685
R809 VOUTN.t20 VOUTN.n185 8.49685
R810 VOUTN.t20 VOUTN.n187 8.49685
R811 VOUTN.t20 VOUTN.n192 8.49685
R812 VOUTN.n156 VOUTN.t23 8.49685
R813 VOUTN.n160 VOUTN.t23 8.49685
R814 VOUTN.n170 VOUTN.t23 8.49685
R815 VOUTN.n174 VOUTN.t23 8.49685
R816 VOUTN.t13 VOUTN.n153 8.49685
R817 VOUTN.t13 VOUTN.n163 8.49685
R818 VOUTN.t13 VOUTN.n167 8.49685
R819 VOUTN.t18 VOUTN.n137 8.49685
R820 VOUTN.t18 VOUTN.n139 8.49685
R821 VOUTN.t18 VOUTN.n144 8.49685
R822 VOUTN.t18 VOUTN.n146 8.49685
R823 VOUTN.t16 VOUTN.n123 8.49685
R824 VOUTN.t16 VOUTN.n128 8.49685
R825 VOUTN.t16 VOUTN.n130 8.49685
R826 VOUTN.t16 VOUTN.n135 8.49685
R827 VOUTN.n99 VOUTN.t4 8.49685
R828 VOUTN.n103 VOUTN.t4 8.49685
R829 VOUTN.n113 VOUTN.t4 8.49685
R830 VOUTN.n117 VOUTN.t4 8.49685
R831 VOUTN.t12 VOUTN.n96 8.49685
R832 VOUTN.t12 VOUTN.n106 8.49685
R833 VOUTN.t12 VOUTN.n110 8.49685
R834 VOUTN.t1 VOUTN.n80 8.49685
R835 VOUTN.t1 VOUTN.n82 8.49685
R836 VOUTN.t1 VOUTN.n87 8.49685
R837 VOUTN.t1 VOUTN.n89 8.49685
R838 VOUTN.t5 VOUTN.n66 8.49685
R839 VOUTN.t5 VOUTN.n71 8.49685
R840 VOUTN.t5 VOUTN.n73 8.49685
R841 VOUTN.t5 VOUTN.n78 8.49685
R842 VOUTN.n43 VOUTN.t24 8.49685
R843 VOUTN.n47 VOUTN.t24 8.49685
R844 VOUTN.n57 VOUTN.t24 8.49685
R845 VOUTN.n61 VOUTN.t24 8.49685
R846 VOUTN.n240 VOUTN.t11 8.49685
R847 VOUTN.t11 VOUTN.n50 8.49685
R848 VOUTN.t11 VOUTN.n54 8.49685
R849 VOUTN.n16 VOUTN.t3 8.49685
R850 VOUTN.n20 VOUTN.t3 8.49685
R851 VOUTN.n30 VOUTN.t3 8.49685
R852 VOUTN.n34 VOUTN.t3 8.49685
R853 VOUTN.n243 VOUTN.t19 8.49685
R854 VOUTN.t19 VOUTN.n23 8.49685
R855 VOUTN.t19 VOUTN.n27 8.49685
R856 VOUTN.t19 VOUTN.n37 8.49685
R857 VOUTN.n283 VOUTN.t25 6.76476
R858 VOUTN.n282 VOUTN.n281 4.40624
R859 VOUTN.n282 VOUTN.n269 4.40624
R860 VOUTN.n282 VOUTN.n268 4.40624
R861 VOUTN.n233 VOUTN.t17 3.4022
R862 VOUTN.n176 VOUTN.t13 3.4022
R863 VOUTN.n119 VOUTN.t12 3.4022
R864 VOUTN.t11 VOUTN.n239 3.4022
R865 VOUTN.n233 VOUTN.t0 3.40192
R866 VOUTN.n176 VOUTN.t23 3.40192
R867 VOUTN.n119 VOUTN.t4 3.40192
R868 VOUTN.n239 VOUTN.t24 3.40192
R869 VOUTN.n284 VOUTN.n283 1.59999
R870 VOUTN.n267 VOUTN.n2 1.13911
R871 VOUTN.n4 VOUTN.n1 1.13264
R872 VOUTN.n264 VOUTN.n3 1.1255
R873 VOUTN.n266 VOUTN.n265 1.1255
R874 VOUTN.n261 VOUTN.n260 0.729408
R875 VOUTN VOUTN.n284 0.672953
R876 VOUTN.n254 VOUTN.n253 0.604502
R877 VOUTN.n258 VOUTN.n257 0.604502
R878 VOUTN.n260 VOUTN.n6 0.6005
R879 VOUTN.n260 VOUTN.n259 0.6005
R880 VOUTN.n250 VOUTN.n249 0.6005
R881 VOUTN.n252 VOUTN.n251 0.6005
R882 VOUTN.n253 VOUTN.n6 0.6005
R883 VOUTN.n259 VOUTN.n258 0.6005
R884 VOUTN.n256 VOUTN.n250 0.6005
R885 VOUTN.n255 VOUTN.n252 0.6005
R886 VOUTN.n9 VOUTN.t14 0.592113
R887 VOUTN.n11 VOUTN.t15 0.592113
R888 VOUTN.n13 VOUTN.t10 0.592113
R889 VOUTN.n7 VOUTN.t2 0.592113
R890 VOUTN.n7 VOUTN.t8 0.59207
R891 VOUTN.n9 VOUTN.t9 0.59207
R892 VOUTN.n11 VOUTN.t6 0.59207
R893 VOUTN.n13 VOUTN.t7 0.59207
R894 VOUTN.n262 VOUTN.n2 0.560516
R895 VOUTN.n263 VOUTN.n262 0.560516
R896 VOUTN.n284 VOUTN.n267 0.560178
R897 VOUTN.n284 VOUTN.n1 0.560178
R898 VOUTN.n261 VOUTN.t22 0.521198
R899 VOUTN.n283 VOUTN.n282 0.444909
R900 VOUTN.n238 VOUTN.n237 0.411739
R901 VOUTN.n277 VOUTN.n276 0.3877
R902 VOUTN.n272 VOUTN.n270 0.3877
R903 VOUTN.n278 VOUTN.n275 0.369262
R904 VOUTN.n273 VOUTN.n271 0.369262
R905 VOUTN.n257 VOUTN.n0 0.304502
R906 VOUTN.n254 VOUTN.n0 0.304502
R907 VOUTN.n260 VOUTN.n5 0.299584
R908 VOUTN.n237 VOUTN.n120 0.27491
R909 VOUTN.n236 VOUTN.n177 0.27491
R910 VOUTN.n235 VOUTN.n234 0.27491
R911 VOUTN VOUTN.n0 0.23299
R912 VOUTN.n246 VOUTN.n245 0.214017
R913 VOUTN.n277 VOUTN.n268 0.190523
R914 VOUTN.n272 VOUTN.n269 0.190523
R915 VOUTN.n281 VOUTN.n270 0.190523
R916 VOUTN.n276 VOUTN.n269 0.190523
R917 VOUTN.n280 VOUTN.n271 0.181769
R918 VOUTN.n279 VOUTN.n278 0.181769
R919 VOUTN.n274 VOUTN.n273 0.181769
R920 VOUTN.n275 VOUTN.n274 0.181769
R921 VOUTN.n8 VOUTN.n7 0.163251
R922 VOUTN.n10 VOUTN.n9 0.163251
R923 VOUTN.n12 VOUTN.n11 0.163251
R924 VOUTN.n245 VOUTN.n13 0.163251
R925 VOUTN.n262 VOUTN.n261 0.151838
R926 VOUTN.n246 VOUTN.n12 0.147515
R927 VOUTN.n247 VOUTN.n10 0.147515
R928 VOUTN.n248 VOUTN.n8 0.147515
R929 VOUTN.n237 VOUTN.n236 0.13733
R930 VOUTN.n236 VOUTN.n235 0.13733
R931 VOUTN.n235 VOUTN.n4 0.120915
R932 VOUTN.n247 VOUTN.n246 0.067002
R933 VOUTN.n248 VOUTN.n247 0.067002
R934 VOUTN.n259 VOUTN.n248 0.0584195
R935 VOUTN.n234 VOUTN.n233 0.0333092
R936 VOUTN.n177 VOUTN.n176 0.0333092
R937 VOUTN.n120 VOUTN.n119 0.0333092
R938 VOUTN.n239 VOUTN.n238 0.0333092
R939 VOUTN.n209 VOUTN.n208 0.0317931
R940 VOUTN.n152 VOUTN.n151 0.0317931
R941 VOUTN.n95 VOUTN.n94 0.0317931
R942 VOUTN.n242 VOUTN.n241 0.0317931
R943 VOUTN.n193 VOUTN.n180 0.0179683
R944 VOUTN.n194 VOUTN.n181 0.0179683
R945 VOUTN.n196 VOUTN.n183 0.0179683
R946 VOUTN.n198 VOUTN.n185 0.0179683
R947 VOUTN.n200 VOUTN.n187 0.0179683
R948 VOUTN.n201 VOUTN.n188 0.0179683
R949 VOUTN.n203 VOUTN.n190 0.0179683
R950 VOUTN.n206 VOUTN.n192 0.0179683
R951 VOUTN.n211 VOUTN.n210 0.0179683
R952 VOUTN.n213 VOUTN.n212 0.0179683
R953 VOUTN.n217 VOUTN.n216 0.0179683
R954 VOUTN.n221 VOUTN.n220 0.0179683
R955 VOUTN.n225 VOUTN.n224 0.0179683
R956 VOUTN.n227 VOUTN.n226 0.0179683
R957 VOUTN.n231 VOUTN.n230 0.0179683
R958 VOUTN.n214 VOUTN.n213 0.0179683
R959 VOUTN.n218 VOUTN.n217 0.0179683
R960 VOUTN.n220 VOUTN.n219 0.0179683
R961 VOUTN.n224 VOUTN.n223 0.0179683
R962 VOUTN.n228 VOUTN.n227 0.0179683
R963 VOUTN.n232 VOUTN.n231 0.0179683
R964 VOUTN.n194 VOUTN.n182 0.0179683
R965 VOUTN.n196 VOUTN.n184 0.0179683
R966 VOUTN.n197 VOUTN.n185 0.0179683
R967 VOUTN.n199 VOUTN.n187 0.0179683
R968 VOUTN.n201 VOUTN.n189 0.0179683
R969 VOUTN.n203 VOUTN.n191 0.0179683
R970 VOUTN.n204 VOUTN.n192 0.0179683
R971 VOUTN.n136 VOUTN.n123 0.0179683
R972 VOUTN.n137 VOUTN.n124 0.0179683
R973 VOUTN.n139 VOUTN.n126 0.0179683
R974 VOUTN.n141 VOUTN.n128 0.0179683
R975 VOUTN.n143 VOUTN.n130 0.0179683
R976 VOUTN.n144 VOUTN.n131 0.0179683
R977 VOUTN.n146 VOUTN.n133 0.0179683
R978 VOUTN.n149 VOUTN.n135 0.0179683
R979 VOUTN.n154 VOUTN.n153 0.0179683
R980 VOUTN.n156 VOUTN.n155 0.0179683
R981 VOUTN.n160 VOUTN.n159 0.0179683
R982 VOUTN.n164 VOUTN.n163 0.0179683
R983 VOUTN.n168 VOUTN.n167 0.0179683
R984 VOUTN.n170 VOUTN.n169 0.0179683
R985 VOUTN.n174 VOUTN.n173 0.0179683
R986 VOUTN.n157 VOUTN.n156 0.0179683
R987 VOUTN.n161 VOUTN.n160 0.0179683
R988 VOUTN.n163 VOUTN.n162 0.0179683
R989 VOUTN.n167 VOUTN.n166 0.0179683
R990 VOUTN.n171 VOUTN.n170 0.0179683
R991 VOUTN.n175 VOUTN.n174 0.0179683
R992 VOUTN.n137 VOUTN.n125 0.0179683
R993 VOUTN.n139 VOUTN.n127 0.0179683
R994 VOUTN.n140 VOUTN.n128 0.0179683
R995 VOUTN.n142 VOUTN.n130 0.0179683
R996 VOUTN.n144 VOUTN.n132 0.0179683
R997 VOUTN.n146 VOUTN.n134 0.0179683
R998 VOUTN.n147 VOUTN.n135 0.0179683
R999 VOUTN.n79 VOUTN.n66 0.0179683
R1000 VOUTN.n80 VOUTN.n67 0.0179683
R1001 VOUTN.n82 VOUTN.n69 0.0179683
R1002 VOUTN.n84 VOUTN.n71 0.0179683
R1003 VOUTN.n86 VOUTN.n73 0.0179683
R1004 VOUTN.n87 VOUTN.n74 0.0179683
R1005 VOUTN.n89 VOUTN.n76 0.0179683
R1006 VOUTN.n92 VOUTN.n78 0.0179683
R1007 VOUTN.n97 VOUTN.n96 0.0179683
R1008 VOUTN.n99 VOUTN.n98 0.0179683
R1009 VOUTN.n103 VOUTN.n102 0.0179683
R1010 VOUTN.n107 VOUTN.n106 0.0179683
R1011 VOUTN.n111 VOUTN.n110 0.0179683
R1012 VOUTN.n113 VOUTN.n112 0.0179683
R1013 VOUTN.n117 VOUTN.n116 0.0179683
R1014 VOUTN.n100 VOUTN.n99 0.0179683
R1015 VOUTN.n104 VOUTN.n103 0.0179683
R1016 VOUTN.n106 VOUTN.n105 0.0179683
R1017 VOUTN.n110 VOUTN.n109 0.0179683
R1018 VOUTN.n114 VOUTN.n113 0.0179683
R1019 VOUTN.n118 VOUTN.n117 0.0179683
R1020 VOUTN.n80 VOUTN.n68 0.0179683
R1021 VOUTN.n82 VOUTN.n70 0.0179683
R1022 VOUTN.n83 VOUTN.n71 0.0179683
R1023 VOUTN.n85 VOUTN.n73 0.0179683
R1024 VOUTN.n87 VOUTN.n75 0.0179683
R1025 VOUTN.n89 VOUTN.n77 0.0179683
R1026 VOUTN.n90 VOUTN.n78 0.0179683
R1027 VOUTN.n243 VOUTN.n14 0.0179683
R1028 VOUTN.n16 VOUTN.n15 0.0179683
R1029 VOUTN.n20 VOUTN.n19 0.0179683
R1030 VOUTN.n24 VOUTN.n23 0.0179683
R1031 VOUTN.n28 VOUTN.n27 0.0179683
R1032 VOUTN.n30 VOUTN.n29 0.0179683
R1033 VOUTN.n34 VOUTN.n33 0.0179683
R1034 VOUTN.n38 VOUTN.n37 0.0179683
R1035 VOUTN.n240 VOUTN.n41 0.0179683
R1036 VOUTN.n43 VOUTN.n42 0.0179683
R1037 VOUTN.n47 VOUTN.n46 0.0179683
R1038 VOUTN.n51 VOUTN.n50 0.0179683
R1039 VOUTN.n55 VOUTN.n54 0.0179683
R1040 VOUTN.n57 VOUTN.n56 0.0179683
R1041 VOUTN.n61 VOUTN.n60 0.0179683
R1042 VOUTN.n44 VOUTN.n43 0.0179683
R1043 VOUTN.n48 VOUTN.n47 0.0179683
R1044 VOUTN.n50 VOUTN.n49 0.0179683
R1045 VOUTN.n54 VOUTN.n53 0.0179683
R1046 VOUTN.n58 VOUTN.n57 0.0179683
R1047 VOUTN.n62 VOUTN.n61 0.0179683
R1048 VOUTN.n17 VOUTN.n16 0.0179683
R1049 VOUTN.n21 VOUTN.n20 0.0179683
R1050 VOUTN.n23 VOUTN.n22 0.0179683
R1051 VOUTN.n27 VOUTN.n26 0.0179683
R1052 VOUTN.n31 VOUTN.n30 0.0179683
R1053 VOUTN.n35 VOUTN.n34 0.0179683
R1054 VOUTN.n37 VOUTN.n36 0.0179683
R1055 VOUTN.n195 VOUTN.n182 0.0178499
R1056 VOUTN.n197 VOUTN.n184 0.0178499
R1057 VOUTN.n199 VOUTN.n186 0.0178499
R1058 VOUTN.n202 VOUTN.n189 0.0178499
R1059 VOUTN.n204 VOUTN.n191 0.0178499
R1060 VOUTN.n207 VOUTN.n179 0.0178499
R1061 VOUTN.n215 VOUTN.n214 0.0178499
R1062 VOUTN.n219 VOUTN.n218 0.0178499
R1063 VOUTN.n223 VOUTN.n222 0.0178499
R1064 VOUTN.n229 VOUTN.n228 0.0178499
R1065 VOUTN.n212 VOUTN.n211 0.0178499
R1066 VOUTN.n216 VOUTN.n215 0.0178499
R1067 VOUTN.n222 VOUTN.n221 0.0178499
R1068 VOUTN.n226 VOUTN.n225 0.0178499
R1069 VOUTN.n230 VOUTN.n229 0.0178499
R1070 VOUTN.n193 VOUTN.n181 0.0178499
R1071 VOUTN.n195 VOUTN.n183 0.0178499
R1072 VOUTN.n198 VOUTN.n186 0.0178499
R1073 VOUTN.n200 VOUTN.n188 0.0178499
R1074 VOUTN.n202 VOUTN.n190 0.0178499
R1075 VOUTN.n207 VOUTN.n206 0.0178499
R1076 VOUTN.n138 VOUTN.n125 0.0178499
R1077 VOUTN.n140 VOUTN.n127 0.0178499
R1078 VOUTN.n142 VOUTN.n129 0.0178499
R1079 VOUTN.n145 VOUTN.n132 0.0178499
R1080 VOUTN.n147 VOUTN.n134 0.0178499
R1081 VOUTN.n150 VOUTN.n122 0.0178499
R1082 VOUTN.n158 VOUTN.n157 0.0178499
R1083 VOUTN.n162 VOUTN.n161 0.0178499
R1084 VOUTN.n166 VOUTN.n165 0.0178499
R1085 VOUTN.n172 VOUTN.n171 0.0178499
R1086 VOUTN.n155 VOUTN.n154 0.0178499
R1087 VOUTN.n159 VOUTN.n158 0.0178499
R1088 VOUTN.n165 VOUTN.n164 0.0178499
R1089 VOUTN.n169 VOUTN.n168 0.0178499
R1090 VOUTN.n173 VOUTN.n172 0.0178499
R1091 VOUTN.n136 VOUTN.n124 0.0178499
R1092 VOUTN.n138 VOUTN.n126 0.0178499
R1093 VOUTN.n141 VOUTN.n129 0.0178499
R1094 VOUTN.n143 VOUTN.n131 0.0178499
R1095 VOUTN.n145 VOUTN.n133 0.0178499
R1096 VOUTN.n150 VOUTN.n149 0.0178499
R1097 VOUTN.n81 VOUTN.n68 0.0178499
R1098 VOUTN.n83 VOUTN.n70 0.0178499
R1099 VOUTN.n85 VOUTN.n72 0.0178499
R1100 VOUTN.n88 VOUTN.n75 0.0178499
R1101 VOUTN.n90 VOUTN.n77 0.0178499
R1102 VOUTN.n93 VOUTN.n65 0.0178499
R1103 VOUTN.n101 VOUTN.n100 0.0178499
R1104 VOUTN.n105 VOUTN.n104 0.0178499
R1105 VOUTN.n109 VOUTN.n108 0.0178499
R1106 VOUTN.n115 VOUTN.n114 0.0178499
R1107 VOUTN.n98 VOUTN.n97 0.0178499
R1108 VOUTN.n102 VOUTN.n101 0.0178499
R1109 VOUTN.n108 VOUTN.n107 0.0178499
R1110 VOUTN.n112 VOUTN.n111 0.0178499
R1111 VOUTN.n116 VOUTN.n115 0.0178499
R1112 VOUTN.n79 VOUTN.n67 0.0178499
R1113 VOUTN.n81 VOUTN.n69 0.0178499
R1114 VOUTN.n84 VOUTN.n72 0.0178499
R1115 VOUTN.n86 VOUTN.n74 0.0178499
R1116 VOUTN.n88 VOUTN.n76 0.0178499
R1117 VOUTN.n93 VOUTN.n92 0.0178499
R1118 VOUTN.n18 VOUTN.n17 0.0178499
R1119 VOUTN.n22 VOUTN.n21 0.0178499
R1120 VOUTN.n26 VOUTN.n25 0.0178499
R1121 VOUTN.n32 VOUTN.n31 0.0178499
R1122 VOUTN.n36 VOUTN.n35 0.0178499
R1123 VOUTN.n40 VOUTN.n39 0.0178499
R1124 VOUTN.n45 VOUTN.n44 0.0178499
R1125 VOUTN.n49 VOUTN.n48 0.0178499
R1126 VOUTN.n53 VOUTN.n52 0.0178499
R1127 VOUTN.n59 VOUTN.n58 0.0178499
R1128 VOUTN.n42 VOUTN.n41 0.0178499
R1129 VOUTN.n46 VOUTN.n45 0.0178499
R1130 VOUTN.n52 VOUTN.n51 0.0178499
R1131 VOUTN.n56 VOUTN.n55 0.0178499
R1132 VOUTN.n60 VOUTN.n59 0.0178499
R1133 VOUTN.n15 VOUTN.n14 0.0178499
R1134 VOUTN.n19 VOUTN.n18 0.0178499
R1135 VOUTN.n25 VOUTN.n24 0.0178499
R1136 VOUTN.n29 VOUTN.n28 0.0178499
R1137 VOUTN.n33 VOUTN.n32 0.0178499
R1138 VOUTN.n39 VOUTN.n38 0.0178499
R1139 VOUTN.n205 VOUTN.n8 0.0161466
R1140 VOUTN.n148 VOUTN.n10 0.0161466
R1141 VOUTN.n91 VOUTN.n12 0.0161466
R1142 VOUTN.n245 VOUTN.n244 0.0161466
R1143 VOUTN.n266 VOUTN.n3 0.0138671
R1144 VOUTN.n265 VOUTN.n264 0.0125
R1145 VOUTN.n210 VOUTN.n209 0.00929337
R1146 VOUTN.n205 VOUTN.n180 0.00929337
R1147 VOUTN.n153 VOUTN.n152 0.00929337
R1148 VOUTN.n148 VOUTN.n123 0.00929337
R1149 VOUTN.n96 VOUTN.n95 0.00929337
R1150 VOUTN.n91 VOUTN.n66 0.00929337
R1151 VOUTN.n241 VOUTN.n240 0.00929337
R1152 VOUTN.n244 VOUTN.n243 0.00929337
R1153 VOUTN.n232 VOUTN.n178 0.00917495
R1154 VOUTN.n208 VOUTN.n179 0.00917495
R1155 VOUTN.n175 VOUTN.n121 0.00917495
R1156 VOUTN.n151 VOUTN.n122 0.00917495
R1157 VOUTN.n118 VOUTN.n64 0.00917495
R1158 VOUTN.n94 VOUTN.n65 0.00917495
R1159 VOUTN.n63 VOUTN.n62 0.00917495
R1160 VOUTN.n242 VOUTN.n40 0.00917495
R1161 VOUTN.n3 VOUTN.n1 0.00764407
R1162 VOUTN.n267 VOUTN.n266 0.00764407
R1163 VOUTN.n258 VOUTN.n250 0.00750498
R1164 VOUTN.n252 VOUTN.n250 0.00750498
R1165 VOUTN.n253 VOUTN.n252 0.00750498
R1166 VOUTN.n256 VOUTN.n255 0.00750498
R1167 VOUTN.n263 VOUTN.n4 0.00696817
R1168 VOUTN.n265 VOUTN.n2 0.00696817
R1169 VOUTN.n264 VOUTN.n263 0.00696817
R1170 VOUTN.n259 VOUTN.n249 0.00619272
R1171 VOUTN.n251 VOUTN.n6 0.00619272
R1172 VOUTN.n234 VOUTN.n178 0.00618966
R1173 VOUTN.n177 VOUTN.n121 0.00618966
R1174 VOUTN.n120 VOUTN.n64 0.00618966
R1175 VOUTN.n238 VOUTN.n63 0.00618966
R1176 VOUTN.n257 VOUTN.n256 0.00446207
R1177 VOUTN.n255 VOUTN.n254 0.00446207
R1178 VOUTN.n249 VOUTN.n5 0.00383292
R1179 VOUTN.n251 VOUTN.n5 0.00383292
R1180 VP.n0 VP.t0 24.0256
R1181 VP VP.n0 0.0388429
R1182 VP.n0 VP 0.00238571
R1183 CMFBin.n0 CMFBin.t26 24.5109
R1184 CMFBin.n12 CMFBin.t0 24.5109
R1185 CMFBin.n0 CMFBin.t25 24.0005
R1186 CMFBin.n1 CMFBin.t24 24.0005
R1187 CMFBin.n2 CMFBin.t23 24.0005
R1188 CMFBin.n3 CMFBin.t22 24.0005
R1189 CMFBin.n4 CMFBin.t21 24.0005
R1190 CMFBin.n5 CMFBin.t20 24.0005
R1191 CMFBin.n6 CMFBin.t19 24.0005
R1192 CMFBin.n7 CMFBin.t18 24.0005
R1193 CMFBin.n8 CMFBin.t17 24.0005
R1194 CMFBin.n9 CMFBin.t16 24.0005
R1195 CMFBin.n10 CMFBin.t15 24.0005
R1196 CMFBin.n11 CMFBin.t14 24.0005
R1197 CMFBin.n24 CMFBin.t13 24.0005
R1198 CMFBin.n23 CMFBin.t12 24.0005
R1199 CMFBin.n22 CMFBin.t11 24.0005
R1200 CMFBin.n21 CMFBin.t10 24.0005
R1201 CMFBin.n20 CMFBin.t9 24.0005
R1202 CMFBin.n19 CMFBin.t8 24.0005
R1203 CMFBin.n18 CMFBin.t7 24.0005
R1204 CMFBin.n17 CMFBin.t6 24.0005
R1205 CMFBin.n16 CMFBin.t5 24.0005
R1206 CMFBin.n15 CMFBin.t4 24.0005
R1207 CMFBin.n14 CMFBin.t3 24.0005
R1208 CMFBin.n13 CMFBin.t2 24.0005
R1209 CMFBin.n12 CMFBin.t1 24.0005
R1210 CMFBin.n11 CMFBin.n10 0.5109
R1211 CMFBin.n10 CMFBin.n9 0.5109
R1212 CMFBin.n9 CMFBin.n8 0.5109
R1213 CMFBin.n8 CMFBin.n7 0.5109
R1214 CMFBin.n7 CMFBin.n6 0.5109
R1215 CMFBin.n6 CMFBin.n5 0.5109
R1216 CMFBin.n5 CMFBin.n4 0.5109
R1217 CMFBin.n4 CMFBin.n3 0.5109
R1218 CMFBin.n3 CMFBin.n2 0.5109
R1219 CMFBin.n2 CMFBin.n1 0.5109
R1220 CMFBin.n1 CMFBin.n0 0.5109
R1221 CMFBin.n13 CMFBin.n12 0.5109
R1222 CMFBin.n14 CMFBin.n13 0.5109
R1223 CMFBin.n15 CMFBin.n14 0.5109
R1224 CMFBin.n16 CMFBin.n15 0.5109
R1225 CMFBin.n17 CMFBin.n16 0.5109
R1226 CMFBin.n18 CMFBin.n17 0.5109
R1227 CMFBin.n19 CMFBin.n18 0.5109
R1228 CMFBin.n20 CMFBin.n19 0.5109
R1229 CMFBin.n21 CMFBin.n20 0.5109
R1230 CMFBin.n22 CMFBin.n21 0.5109
R1231 CMFBin.n23 CMFBin.n22 0.5109
R1232 CMFBin.n24 CMFBin.n23 0.3349
R1233 CMFBin CMFBin.n11 0.2909
R1234 CMFBin CMFBin.n24 0.0445
R1235 VPout VPout.n0 17.8142
R1236 VPout.n0 VPout.t0 15.0571
R1237 VPout.n0 VPout.t1 15.0492
R1238 VN VN.t0 24.0307
R1239 VNin.n0 VNin.t0 8.39032
R1240 VNin VNin.n0 0.00482787
R1241 VNin.n0 VNin 0.00410656
R1242 VPin VPin.t0 8.39717
R1243 Vop.n309 Vop.t156 22.5917
R1244 Vop Vop.t158 21.5249
R1245 Vop.n310 Vop.t157 13.9465
R1246 Vop.n310 Vop.n309 8.02022
R1247 Vop.n309 Vop.n308 6.34129
R1248 Vop.n108 Vop.n107 5.40186
R1249 Vop.n110 Vop.n52 4.79005
R1250 Vop.n111 Vop.n51 4.79005
R1251 Vop.n109 Vop.n53 4.79005
R1252 Vop.n108 Vop.n54 4.78992
R1253 Vop.n250 Vop.t52 4.58861
R1254 Vop.n205 Vop.t34 4.58861
R1255 Vop.n196 Vop.t35 4.58861
R1256 Vop.n199 Vop.t37 4.58861
R1257 Vop.n194 Vop.t128 4.58861
R1258 Vop.n54 Vop.t45 4.14532
R1259 Vop.n52 Vop.t48 4.14519
R1260 Vop.n51 Vop.t47 4.14519
R1261 Vop.n53 Vop.t153 4.14519
R1262 Vop.n107 Vop.t46 4.14519
R1263 Vop.n249 Vop.t38 4.11168
R1264 Vop.n246 Vop.t41 4.11168
R1265 Vop.n206 Vop.t150 4.11168
R1266 Vop.n204 Vop.t140 4.11168
R1267 Vop.n218 Vop.t136 4.11168
R1268 Vop.n16 Vop.t66 4.11168
R1269 Vop.n230 Vop.t59 4.11168
R1270 Vop.n10 Vop.t65 4.11168
R1271 Vop.n137 Vop.t75 4.11168
R1272 Vop.n140 Vop.t144 4.11168
R1273 Vop.n32 Vop.t120 4.11168
R1274 Vop.n89 Vop.t117 4.11168
R1275 Vop.n86 Vop.t154 4.11168
R1276 Vop.n195 Vop.t129 4.11168
R1277 Vop.n200 Vop.t130 4.11168
R1278 Vop.n191 Vop.t148 4.11168
R1279 Vop.n188 Vop.t146 4.11168
R1280 Vop.n185 Vop.t81 4.11168
R1281 Vop.n182 Vop.t78 4.11168
R1282 Vop.n22 Vop.t92 4.11168
R1283 Vop.n160 Vop.t77 4.11168
R1284 Vop.n25 Vop.t105 4.11168
R1285 Vop.n78 Vop.t97 4.11168
R1286 Vop.n75 Vop.t112 4.11168
R1287 Vop.n101 Vop.t107 4.11168
R1288 Vop.n57 Vop.t43 4.11168
R1289 Vop.n82 Vop.t50 4.11156
R1290 Vop.n50 Vop.t106 4.11156
R1291 Vop.n47 Vop.t116 4.11156
R1292 Vop.n44 Vop.t124 4.11156
R1293 Vop.n41 Vop.t119 4.11156
R1294 Vop.n35 Vop.t131 4.11156
R1295 Vop.n131 Vop.t141 4.11156
R1296 Vop.n8 Vop.t64 4.11156
R1297 Vop.n237 Vop.t61 4.11156
R1298 Vop.n240 Vop.t139 4.11156
R1299 Vop.n243 Vop.t83 4.11156
R1300 Vop.n62 Vop.t51 4.11156
R1301 Vop.n65 Vop.t123 4.11156
R1302 Vop.n95 Vop.t111 4.11156
R1303 Vop.n29 Vop.t126 4.11156
R1304 Vop.n147 Vop.t145 4.11156
R1305 Vop.n153 Vop.t76 4.11156
R1306 Vop.n150 Vop.t91 4.11156
R1307 Vop.n13 Vop.t60 4.11156
R1308 Vop.n224 Vop.t67 4.11156
R1309 Vop.n19 Vop.t137 4.11156
R1310 Vop.n212 Vop.t147 4.11156
R1311 Vop.n106 Vop.t44 4.11156
R1312 Vop.n59 Vop.t108 4.11156
R1313 Vop.n68 Vop.t118 4.11156
R1314 Vop.n72 Vop.t98 4.11156
R1315 Vop.n69 Vop.t101 4.11156
R1316 Vop.n23 Vop.t90 4.11156
R1317 Vop.n166 Vop.t151 4.11156
R1318 Vop.n176 Vop.t79 4.11156
R1319 Vop.n173 Vop.t82 4.11156
R1320 Vop.n170 Vop.t149 4.11156
R1321 Vop.n167 Vop.t36 4.11156
R1322 Vop.n193 Vop.t152 4.11156
R1323 Vop.n48 Vop.t49 4.1098
R1324 Vop.n45 Vop.t110 4.1098
R1325 Vop.n42 Vop.t125 4.1098
R1326 Vop.n39 Vop.t104 4.1098
R1327 Vop.n130 Vop.t86 4.1098
R1328 Vop.n132 Vop.t74 4.1098
R1329 Vop.n236 Vop.t80 4.1098
R1330 Vop.n239 Vop.t70 4.1098
R1331 Vop.n242 Vop.t84 4.1098
R1332 Vop.n248 Vop.t39 4.1098
R1333 Vop.n245 Vop.t68 4.1098
R1334 Vop.n207 Vop.t40 4.1098
R1335 Vop.n17 Vop.t69 4.1098
R1336 Vop.n219 Vop.t85 4.1098
R1337 Vop.n11 Vop.t71 4.1098
R1338 Vop.n231 Vop.t62 4.1098
R1339 Vop.n33 Vop.t72 4.1098
R1340 Vop.n138 Vop.t87 4.1098
R1341 Vop.n141 Vop.t99 4.1098
R1342 Vop.n90 Vop.t127 4.1098
R1343 Vop.n88 Vop.t113 4.1098
R1344 Vop.n85 Vop.t96 4.1098
R1345 Vop.n64 Vop.t109 4.1098
R1346 Vop.n96 Vop.t155 4.1098
R1347 Vop.n66 Vop.t94 4.1098
R1348 Vop.n146 Vop.t100 4.1098
R1349 Vop.n154 Vop.t88 4.1098
R1350 Vop.n151 Vop.t73 4.1098
R1351 Vop.n148 Vop.t63 4.1098
R1352 Vop.n225 Vop.t55 4.1098
R1353 Vop.n14 Vop.t138 4.1098
R1354 Vop.n213 Vop.t134 4.1098
R1355 Vop.n20 Vop.t33 4.1098
R1356 Vop.n201 Vop.t31 4.1098
R1357 Vop.n190 Vop.t135 4.1098
R1358 Vop.n187 Vop.t133 4.1098
R1359 Vop.n184 Vop.t56 4.1098
R1360 Vop.n181 Vop.t54 4.1098
R1361 Vop.n161 Vop.t57 4.1098
R1362 Vop.n159 Vop.t89 4.1098
R1363 Vop.n76 Vop.t103 4.1098
R1364 Vop.n79 Vop.t95 4.1098
R1365 Vop.n58 Vop.t121 4.1098
R1366 Vop.n102 Vop.t114 4.1098
R1367 Vop.n55 Vop.t115 4.1098
R1368 Vop.n67 Vop.t122 4.1098
R1369 Vop.n73 Vop.t102 4.1098
R1370 Vop.n70 Vop.t142 4.1098
R1371 Vop.n26 Vop.t143 4.1098
R1372 Vop.n165 Vop.t58 4.1098
R1373 Vop.n177 Vop.t53 4.1098
R1374 Vop.n174 Vop.t93 4.1098
R1375 Vop.n171 Vop.t132 4.1098
R1376 Vop.n168 Vop.t42 4.1098
R1377 Vop.n192 Vop.t32 4.1098
R1378 Vop.n172 Vop.n15 3.402
R1379 Vop.n175 Vop.n12 3.402
R1380 Vop.n179 Vop.n178 3.402
R1381 Vop.n164 Vop.n163 3.402
R1382 Vop.n157 Vop.n27 3.402
R1383 Vop.n71 Vop.n30 3.402
R1384 Vop.n81 Vop.n74 3.402
R1385 Vop.n99 Vop.n60 3.402
R1386 Vop.n169 Vop.n18 3.402
R1387 Vop.n105 Vop.n104 3.402
R1388 Vop.n203 Vop.n21 3.402
R1389 Vop.n198 Vop.n194 3.402
R1390 Vop.n46 Vop.n37 3.0005
R1391 Vop.n43 Vop.n36 3.0005
R1392 Vop.n40 Vop.n31 3.0005
R1393 Vop.n129 Vop.n128 3.0005
R1394 Vop.n134 Vop.n133 3.0005
R1395 Vop.n235 Vop.n234 3.0005
R1396 Vop.n238 Vop.n1 3.0005
R1397 Vop.n241 Vop.n3 3.0005
R1398 Vop.n244 Vop.n4 3.0005
R1399 Vop.n217 Vop.n216 3.0005
R1400 Vop.n221 Vop.n220 3.0005
R1401 Vop.n229 Vop.n228 3.0005
R1402 Vop.n233 Vop.n232 3.0005
R1403 Vop.n136 Vop.n135 3.0005
R1404 Vop.n139 Vop.n28 3.0005
R1405 Vop.n143 Vop.n142 3.0005
R1406 Vop.n92 Vop.n91 3.0005
R1407 Vop.n87 Vop.n61 3.0005
R1408 Vop.n84 Vop.n83 3.0005
R1409 Vop.n49 Vop.n38 3.0005
R1410 Vop.n63 Vop.n56 3.0005
R1411 Vop.n98 Vop.n97 3.0005
R1412 Vop.n94 Vop.n93 3.0005
R1413 Vop.n145 Vop.n144 3.0005
R1414 Vop.n156 Vop.n155 3.0005
R1415 Vop.n152 Vop.n24 3.0005
R1416 Vop.n149 Vop.n9 3.0005
R1417 Vop.n227 Vop.n226 3.0005
R1418 Vop.n223 Vop.n222 3.0005
R1419 Vop.n215 Vop.n214 3.0005
R1420 Vop.n211 Vop.n210 3.0005
R1421 Vop.n209 Vop.n208 3.0005
R1422 Vop.n247 Vop.n5 3.0005
R1423 Vop.n203 Vop.n202 3.0005
R1424 Vop.n189 Vop.n18 3.0005
R1425 Vop.n186 Vop.n15 3.0005
R1426 Vop.n183 Vop.n12 3.0005
R1427 Vop.n180 Vop.n179 3.0005
R1428 Vop.n163 Vop.n162 3.0005
R1429 Vop.n158 Vop.n157 3.0005
R1430 Vop.n77 Vop.n30 3.0005
R1431 Vop.n81 Vop.n80 3.0005
R1432 Vop.n100 Vop.n99 3.0005
R1433 Vop.n104 Vop.n103 3.0005
R1434 Vop.n199 Vop.n198 3.0005
R1435 Vop.n197 Vop.n196 3.0005
R1436 Vop.n205 Vop.n7 3.0005
R1437 Vop.n251 Vop.n250 3.0005
R1438 Vop.n265 Vop.n264 2.79264
R1439 Vop.n262 Vop.n261 2.79264
R1440 Vop.n278 Vop.n277 2.79264
R1441 Vop.n284 Vop.n283 2.79264
R1442 Vop.n255 Vop.n253 2.79264
R1443 Vop.n296 Vop.n295 2.79204
R1444 Vop.n292 Vop.n291 2.75434
R1445 Vop.n299 Vop.n298 2.754
R1446 Vop.n266 Vop.n259 2.75399
R1447 Vop.n271 Vop.n270 2.75399
R1448 Vop.n275 Vop.n274 2.75399
R1449 Vop.n286 Vop.n285 2.75399
R1450 Vop.n272 Vop.n259 2.70125
R1451 Vop.n272 Vop.n271 2.56786
R1452 Vop.n274 Vop.n273 2.56786
R1453 Vop.n285 Vop.n252 2.56786
R1454 Vop.n300 Vop.n299 2.56783
R1455 Vop.n293 Vop.n292 2.56718
R1456 Vop.n120 Vop.n115 2.28094
R1457 Vop.n124 Vop.n123 2.26567
R1458 Vop.n123 Vop.n122 2.2505
R1459 Vop.n121 Vop.n117 2.2505
R1460 Vop.n117 Vop.n116 2.2505
R1461 Vop.n119 Vop.n118 2.2505
R1462 Vop.n263 Vop.t14 2.04564
R1463 Vop.n260 Vop.t15 2.04564
R1464 Vop.n279 Vop.t26 2.04564
R1465 Vop.n282 Vop.t4 2.04564
R1466 Vop.n256 Vop.t5 2.04564
R1467 Vop.n294 Vop.t29 2.04293
R1468 Vop.n264 Vop.n263 1.22501
R1469 Vop.n261 Vop.n260 1.22501
R1470 Vop.n279 Vop.n278 1.22501
R1471 Vop.n283 Vop.n282 1.22501
R1472 Vop.n256 Vop.n255 1.22501
R1473 Vop.n291 Vop.n290 1.22501
R1474 Vop.n267 Vop.n266 1.22386
R1475 Vop.n270 Vop.n269 1.22386
R1476 Vop.n276 Vop.n275 1.22386
R1477 Vop.n287 Vop.n286 1.22386
R1478 Vop.n298 Vop.n297 1.22386
R1479 Vop.n295 Vop.n294 1.22386
R1480 Vop.n297 Vop.n296 1.22065
R1481 Vop.n267 Vop.n265 1.21996
R1482 Vop.n269 Vop.n262 1.21996
R1483 Vop.n277 Vop.n276 1.21996
R1484 Vop.n287 Vop.n284 1.21996
R1485 Vop.n290 Vop.n253 1.21996
R1486 Vop.n121 Vop.n120 1.15554
R1487 Vop.n125 Vop.n124 1.11866
R1488 Vop.n125 Vop.n115 1.11866
R1489 Vop.n249 Vop.n248 1.04934
R1490 Vop.n246 Vop.n245 1.04934
R1491 Vop.n207 Vop.n206 1.04934
R1492 Vop.n204 Vop.n17 1.04934
R1493 Vop.n219 Vop.n218 1.04934
R1494 Vop.n16 Vop.n11 1.04934
R1495 Vop.n231 Vop.n230 1.04934
R1496 Vop.n33 Vop.n10 1.04934
R1497 Vop.n138 Vop.n137 1.04934
R1498 Vop.n141 Vop.n140 1.04934
R1499 Vop.n90 Vop.n32 1.04934
R1500 Vop.n89 Vop.n88 1.04934
R1501 Vop.n86 Vop.n85 1.04934
R1502 Vop.n195 Vop.n20 1.04934
R1503 Vop.n201 Vop.n200 1.04934
R1504 Vop.n191 Vop.n190 1.04934
R1505 Vop.n188 Vop.n187 1.04934
R1506 Vop.n185 Vop.n184 1.04934
R1507 Vop.n182 Vop.n181 1.04934
R1508 Vop.n161 Vop.n22 1.04934
R1509 Vop.n160 Vop.n159 1.04934
R1510 Vop.n76 Vop.n25 1.04934
R1511 Vop.n79 Vop.n78 1.04934
R1512 Vop.n75 Vop.n58 1.04934
R1513 Vop.n102 Vop.n101 1.04934
R1514 Vop.n48 Vop.n47 1.04921
R1515 Vop.n45 Vop.n44 1.04921
R1516 Vop.n42 Vop.n41 1.04921
R1517 Vop.n39 Vop.n35 1.04921
R1518 Vop.n131 Vop.n130 1.04921
R1519 Vop.n132 Vop.n8 1.04921
R1520 Vop.n237 Vop.n236 1.04921
R1521 Vop.n240 Vop.n239 1.04921
R1522 Vop.n243 Vop.n242 1.04921
R1523 Vop.n65 Vop.n64 1.04921
R1524 Vop.n96 Vop.n95 1.04921
R1525 Vop.n66 Vop.n29 1.04921
R1526 Vop.n147 Vop.n146 1.04921
R1527 Vop.n154 Vop.n153 1.04921
R1528 Vop.n151 Vop.n150 1.04921
R1529 Vop.n148 Vop.n13 1.04921
R1530 Vop.n225 Vop.n224 1.04921
R1531 Vop.n19 Vop.n14 1.04921
R1532 Vop.n213 Vop.n212 1.04921
R1533 Vop.n59 Vop.n55 1.04921
R1534 Vop.n68 Vop.n67 1.04921
R1535 Vop.n73 Vop.n72 1.04921
R1536 Vop.n70 Vop.n69 1.04921
R1537 Vop.n26 Vop.n23 1.04921
R1538 Vop.n166 Vop.n165 1.04921
R1539 Vop.n177 Vop.n176 1.04921
R1540 Vop.n174 Vop.n173 1.04921
R1541 Vop.n171 Vop.n170 1.04921
R1542 Vop.n168 Vop.n167 1.04921
R1543 Vop.n193 Vop.n192 1.04921
R1544 Vop.n57 Vop.n54 1.00584
R1545 Vop.n82 Vop.n52 1.00558
R1546 Vop.n51 Vop.n50 1.00558
R1547 Vop.n62 Vop.n53 1.00558
R1548 Vop.n107 Vop.n106 1.00558
R1549 Vop.n268 Vop.n267 0.967195
R1550 Vop.n263 Vop.n258 0.967195
R1551 Vop.n288 Vop.n287 0.9005
R1552 Vop.n276 Vop.n254 0.9005
R1553 Vop.n269 Vop.n268 0.9005
R1554 Vop.n290 Vop.n289 0.9005
R1555 Vop.n297 Vop.n6 0.9005
R1556 Vop.n294 Vop.n2 0.9005
R1557 Vop.n257 Vop.n256 0.9005
R1558 Vop.n282 Vop.n281 0.9005
R1559 Vop.n280 Vop.n279 0.9005
R1560 Vop.n260 Vop.n258 0.9005
R1561 Vop.n292 Vop.t9 0.863268
R1562 Vop.n259 Vop.t25 0.862916
R1563 Vop.n271 Vop.t6 0.862916
R1564 Vop.n274 Vop.t7 0.862916
R1565 Vop.n285 Vop.t8 0.862916
R1566 Vop.n299 Vop.t28 0.862889
R1567 Vop.n265 Vop.t16 0.82619
R1568 Vop.n262 Vop.t0 0.82619
R1569 Vop.n277 Vop.t1 0.82619
R1570 Vop.n284 Vop.t24 0.82619
R1571 Vop.n253 Vop.t10 0.82619
R1572 Vop.n264 Vop.t23 0.826088
R1573 Vop.n261 Vop.t12 0.826088
R1574 Vop.n278 Vop.t13 0.826088
R1575 Vop.n283 Vop.t2 0.826088
R1576 Vop.n255 Vop.t3 0.826088
R1577 Vop.n291 Vop.t21 0.826088
R1578 Vop.n266 Vop.t19 0.825668
R1579 Vop.n270 Vop.t17 0.825668
R1580 Vop.n275 Vop.t18 0.825668
R1581 Vop.n286 Vop.t20 0.825668
R1582 Vop.n298 Vop.t27 0.825668
R1583 Vop.n295 Vop.t22 0.825668
R1584 Vop.n296 Vop.t11 0.825642
R1585 Vop.n109 Vop.n108 0.612309
R1586 Vop.n110 Vop.n109 0.612309
R1587 Vop.n111 Vop.n110 0.612309
R1588 Vop.n112 Vop.n111 0.534073
R1589 Vop.n49 Vop.n48 0.479315
R1590 Vop.n46 Vop.n45 0.479315
R1591 Vop.n43 Vop.n42 0.479315
R1592 Vop.n40 Vop.n39 0.479315
R1593 Vop.n130 Vop.n129 0.479315
R1594 Vop.n133 Vop.n132 0.479315
R1595 Vop.n236 Vop.n235 0.479315
R1596 Vop.n239 Vop.n238 0.479315
R1597 Vop.n242 Vop.n241 0.479315
R1598 Vop.n248 Vop.n247 0.479315
R1599 Vop.n245 Vop.n244 0.479315
R1600 Vop.n208 Vop.n207 0.479315
R1601 Vop.n217 Vop.n17 0.479315
R1602 Vop.n220 Vop.n219 0.479315
R1603 Vop.n229 Vop.n11 0.479315
R1604 Vop.n232 Vop.n231 0.479315
R1605 Vop.n136 Vop.n33 0.479315
R1606 Vop.n139 Vop.n138 0.479315
R1607 Vop.n142 Vop.n141 0.479315
R1608 Vop.n91 Vop.n90 0.479315
R1609 Vop.n88 Vop.n87 0.479315
R1610 Vop.n85 Vop.n84 0.479315
R1611 Vop.n64 Vop.n63 0.479315
R1612 Vop.n97 Vop.n96 0.479315
R1613 Vop.n94 Vop.n66 0.479315
R1614 Vop.n146 Vop.n145 0.479315
R1615 Vop.n155 Vop.n154 0.479315
R1616 Vop.n152 Vop.n151 0.479315
R1617 Vop.n149 Vop.n148 0.479315
R1618 Vop.n226 Vop.n225 0.479315
R1619 Vop.n223 Vop.n14 0.479315
R1620 Vop.n214 Vop.n213 0.479315
R1621 Vop.n211 Vop.n20 0.479315
R1622 Vop.n202 Vop.n201 0.479315
R1623 Vop.n190 Vop.n189 0.479315
R1624 Vop.n187 Vop.n186 0.479315
R1625 Vop.n184 Vop.n183 0.479315
R1626 Vop.n181 Vop.n180 0.479315
R1627 Vop.n162 Vop.n161 0.479315
R1628 Vop.n159 Vop.n158 0.479315
R1629 Vop.n77 Vop.n76 0.479315
R1630 Vop.n80 Vop.n79 0.479315
R1631 Vop.n100 Vop.n58 0.479315
R1632 Vop.n103 Vop.n102 0.479315
R1633 Vop.n105 Vop.n55 0.479315
R1634 Vop.n67 Vop.n60 0.479315
R1635 Vop.n74 Vop.n73 0.479315
R1636 Vop.n71 Vop.n70 0.479315
R1637 Vop.n27 Vop.n26 0.479315
R1638 Vop.n165 Vop.n164 0.479315
R1639 Vop.n178 Vop.n177 0.479315
R1640 Vop.n175 Vop.n174 0.479315
R1641 Vop.n172 Vop.n171 0.479315
R1642 Vop.n169 Vop.n168 0.479315
R1643 Vop.n192 Vop.n21 0.479315
R1644 Vop.n84 Vop.n82 0.439086
R1645 Vop.n50 Vop.n49 0.439086
R1646 Vop.n47 Vop.n46 0.439086
R1647 Vop.n44 Vop.n43 0.439086
R1648 Vop.n41 Vop.n40 0.439086
R1649 Vop.n129 Vop.n35 0.439086
R1650 Vop.n133 Vop.n131 0.439086
R1651 Vop.n235 Vop.n8 0.439086
R1652 Vop.n238 Vop.n237 0.439086
R1653 Vop.n241 Vop.n240 0.439086
R1654 Vop.n244 Vop.n243 0.439086
R1655 Vop.n63 Vop.n62 0.439086
R1656 Vop.n97 Vop.n65 0.439086
R1657 Vop.n95 Vop.n94 0.439086
R1658 Vop.n145 Vop.n29 0.439086
R1659 Vop.n155 Vop.n147 0.439086
R1660 Vop.n153 Vop.n152 0.439086
R1661 Vop.n150 Vop.n149 0.439086
R1662 Vop.n226 Vop.n13 0.439086
R1663 Vop.n224 Vop.n223 0.439086
R1664 Vop.n214 Vop.n19 0.439086
R1665 Vop.n212 Vop.n211 0.439086
R1666 Vop.n106 Vop.n105 0.439086
R1667 Vop.n60 Vop.n59 0.439086
R1668 Vop.n74 Vop.n68 0.439086
R1669 Vop.n72 Vop.n71 0.439086
R1670 Vop.n69 Vop.n27 0.439086
R1671 Vop.n164 Vop.n23 0.439086
R1672 Vop.n178 Vop.n166 0.439086
R1673 Vop.n176 Vop.n175 0.439086
R1674 Vop.n173 Vop.n172 0.439086
R1675 Vop.n170 Vop.n169 0.439086
R1676 Vop.n167 Vop.n21 0.439086
R1677 Vop.n194 Vop.n193 0.439086
R1678 Vop.n250 Vop.n249 0.438949
R1679 Vop.n247 Vop.n246 0.438949
R1680 Vop.n206 Vop.n205 0.438949
R1681 Vop.n208 Vop.n204 0.438949
R1682 Vop.n218 Vop.n217 0.438949
R1683 Vop.n220 Vop.n16 0.438949
R1684 Vop.n230 Vop.n229 0.438949
R1685 Vop.n232 Vop.n10 0.438949
R1686 Vop.n137 Vop.n136 0.438949
R1687 Vop.n140 Vop.n139 0.438949
R1688 Vop.n142 Vop.n32 0.438949
R1689 Vop.n91 Vop.n89 0.438949
R1690 Vop.n87 Vop.n86 0.438949
R1691 Vop.n196 Vop.n195 0.438949
R1692 Vop.n200 Vop.n199 0.438949
R1693 Vop.n202 Vop.n191 0.438949
R1694 Vop.n189 Vop.n188 0.438949
R1695 Vop.n186 Vop.n185 0.438949
R1696 Vop.n183 Vop.n182 0.438949
R1697 Vop.n180 Vop.n22 0.438949
R1698 Vop.n162 Vop.n160 0.438949
R1699 Vop.n158 Vop.n25 0.438949
R1700 Vop.n78 Vop.n77 0.438949
R1701 Vop.n80 Vop.n75 0.438949
R1702 Vop.n101 Vop.n100 0.438949
R1703 Vop.n103 Vop.n57 0.438949
R1704 Vop.n222 Vop.n15 0.402
R1705 Vop.n222 Vop.n221 0.402
R1706 Vop.n221 Vop.n3 0.402
R1707 Vop.n227 Vop.n12 0.402
R1708 Vop.n228 Vop.n227 0.402
R1709 Vop.n228 Vop.n1 0.402
R1710 Vop.n179 Vop.n9 0.402
R1711 Vop.n233 Vop.n9 0.402
R1712 Vop.n234 Vop.n233 0.402
R1713 Vop.n163 Vop.n24 0.402
R1714 Vop.n135 Vop.n24 0.402
R1715 Vop.n135 Vop.n134 0.402
R1716 Vop.n157 Vop.n156 0.402
R1717 Vop.n156 Vop.n28 0.402
R1718 Vop.n128 Vop.n28 0.402
R1719 Vop.n144 Vop.n30 0.402
R1720 Vop.n144 Vop.n143 0.402
R1721 Vop.n143 Vop.n31 0.402
R1722 Vop.n93 Vop.n81 0.402
R1723 Vop.n93 Vop.n92 0.402
R1724 Vop.n92 Vop.n36 0.402
R1725 Vop.n99 Vop.n98 0.402
R1726 Vop.n98 Vop.n61 0.402
R1727 Vop.n61 Vop.n37 0.402
R1728 Vop.n215 Vop.n18 0.402
R1729 Vop.n216 Vop.n215 0.402
R1730 Vop.n216 Vop.n4 0.402
R1731 Vop.n104 Vop.n56 0.402
R1732 Vop.n83 Vop.n56 0.402
R1733 Vop.n83 Vop.n38 0.402
R1734 Vop.n210 Vop.n203 0.402
R1735 Vop.n210 Vop.n209 0.402
R1736 Vop.n209 Vop.n5 0.402
R1737 Vop.n198 Vop.n197 0.402
R1738 Vop.n197 Vop.n7 0.402
R1739 Vop.n251 Vop.n7 0.402
R1740 Vop.n305 Vop.n3 0.3085
R1741 Vop.n307 Vop.n1 0.3085
R1742 Vop.n234 Vop.n0 0.3085
R1743 Vop.n134 Vop.n34 0.3085
R1744 Vop.n128 Vop.n127 0.3085
R1745 Vop.n126 Vop.n31 0.3085
R1746 Vop.n114 Vop.n36 0.3085
R1747 Vop.n113 Vop.n37 0.3085
R1748 Vop.n304 Vop.n4 0.3085
R1749 Vop.n112 Vop.n38 0.3085
R1750 Vop.n303 Vop.n5 0.3085
R1751 Vop.n301 Vop.n251 0.3085
R1752 Vop.n301 Vop.n300 0.215023
R1753 Vop.n122 Vop.t30 0.188525
R1754 Vop Vop.n310 0.159626
R1755 Vop.n300 Vop.n293 0.133889
R1756 Vop.n293 Vop.n252 0.133889
R1757 Vop.n273 Vop.n252 0.133889
R1758 Vop.n273 Vop.n272 0.133889
R1759 Vop.n113 Vop.n112 0.07002
R1760 Vop.n114 Vop.n113 0.07002
R1761 Vop.n127 Vop.n126 0.07002
R1762 Vop.n127 Vop.n34 0.07002
R1763 Vop.n34 Vop.n0 0.07002
R1764 Vop.n305 Vop.n304 0.07002
R1765 Vop.n304 Vop.n303 0.07002
R1766 Vop.n303 Vop.n302 0.06914
R1767 Vop.n289 Vop.n6 0.0671947
R1768 Vop.n289 Vop.n288 0.0671947
R1769 Vop.n288 Vop.n254 0.0671947
R1770 Vop.n268 Vop.n254 0.0671947
R1771 Vop.n257 Vop.n2 0.0671947
R1772 Vop.n281 Vop.n257 0.0671947
R1773 Vop.n281 Vop.n280 0.0671947
R1774 Vop.n280 Vop.n258 0.0671947
R1775 Vop.n307 Vop.n306 0.05726
R1776 Vop.n308 Vop.n0 0.04373
R1777 Vop.n125 Vop.n114 0.04351
R1778 Vop.n122 Vop.n121 0.0300385
R1779 Vop.n119 Vop.n117 0.0300385
R1780 Vop.n123 Vop.n117 0.0300385
R1781 Vop.n118 Vop.n116 0.0300385
R1782 Vop.n126 Vop.n125 0.02701
R1783 Vop.n308 Vop.n307 0.02679
R1784 Vop.n118 Vop.n115 0.0156729
R1785 Vop.n124 Vop.n116 0.0156729
R1786 Vop.n120 Vop.n119 0.0155778
R1787 Vop.n306 Vop.n305 0.01326
R1788 Vop.n302 Vop.n6 0.00953158
R1789 Vop.n306 Vop.n2 0.00953158
R1790 Vop.n302 Vop.n301 0.00138
R1791 VNout VNout.n0 17.7545
R1792 VNout.n0 VNout.t0 15.0561
R1793 VNout.n0 VNout.t1 15.0502
R1794 Von.n309 Von.t156 22.5974
R1795 Von Von.t158 17.2244
R1796 Von.n310 Von.t157 13.9065
R1797 Von.n310 Von.n309 7.98542
R1798 Von.n309 Von.n308 6.3384
R1799 Von.n124 Von.n123 5.40186
R1800 Von.n122 Von.n52 4.79005
R1801 Von.n123 Von.n30 4.79005
R1802 Von.n121 Von.n53 4.79005
R1803 Von.n120 Von.n54 4.78992
R1804 Von.n205 Von.t65 4.58861
R1805 Von.n207 Von.t138 4.58861
R1806 Von.n202 Von.t140 4.58861
R1807 Von.n188 Von.t141 4.58861
R1808 Von.n250 Von.t139 4.58861
R1809 Von.n54 Von.t59 4.14532
R1810 Von.n52 Von.t52 4.14519
R1811 Von.n124 Von.t66 4.14519
R1812 Von.n30 Von.t51 4.14519
R1813 Von.n53 Von.t58 4.14519
R1814 Von.n204 Von.t137 4.11168
R1815 Von.n213 Von.t123 4.11168
R1816 Von.n178 Von.t132 4.11168
R1817 Von.n162 Von.t40 4.11168
R1818 Von.n165 Von.t73 4.11168
R1819 Von.n161 Von.t106 4.11168
R1820 Von.n18 Von.t91 4.11168
R1821 Von.n149 Von.t83 4.11168
R1822 Von.n22 Von.t67 4.11168
R1823 Von.n137 Von.t111 4.11168
R1824 Von.n208 Von.t60 4.11168
R1825 Von.n201 Von.t61 4.11168
R1826 Von.n198 Von.t120 4.11168
R1827 Von.n195 Von.t49 4.11168
R1828 Von.n224 Von.t37 4.11168
R1829 Von.n13 Von.t39 4.11168
R1830 Von.n33 Von.t72 4.11168
R1831 Von.n36 Von.t105 4.11168
R1832 Von.n39 Von.t142 4.11168
R1833 Von.n42 Von.t150 4.11168
R1834 Von.n45 Von.t108 4.11168
R1835 Von.n48 Von.t96 4.11168
R1836 Von.n249 Von.t136 4.11168
R1837 Von.n246 Von.t135 4.11168
R1838 Von.n243 Von.t126 4.11168
R1839 Von.n240 Von.t35 4.11168
R1840 Von.n237 Von.t98 4.11168
R1841 Von.n8 Von.t76 4.11168
R1842 Von.n109 Von.t82 4.11168
R1843 Von.n106 Von.t94 4.11168
R1844 Von.n103 Von.t152 4.11168
R1845 Von.n100 Von.t110 4.11168
R1846 Von.n97 Von.t54 4.11168
R1847 Von.n94 Von.t117 4.11168
R1848 Von.n51 Von.t118 4.11156
R1849 Von.n125 Von.t30 4.11156
R1850 Von.n26 Von.t114 4.11156
R1851 Von.n28 Von.t31 4.11156
R1852 Von.n131 Von.t95 4.11156
R1853 Von.n24 Von.t112 4.11156
R1854 Von.n143 Von.t149 4.11156
R1855 Von.n20 Von.t84 4.11156
R1856 Von.n155 Von.t104 4.11156
R1857 Von.n17 Von.t71 4.11156
R1858 Von.n171 Von.t38 4.11156
R1859 Von.n174 Von.t36 4.11156
R1860 Von.n218 Von.t48 4.11156
R1861 Von.n194 Von.t127 4.11156
R1862 Von.n70 Von.t119 4.11156
R1863 Von.n74 Von.t53 4.11156
R1864 Von.n78 Von.t109 4.11156
R1865 Von.n82 Von.t151 4.11156
R1866 Von.n86 Von.t93 4.11156
R1867 Von.n90 Von.t81 4.11156
R1868 Von.n10 Von.t77 4.11156
R1869 Von.n230 Von.t99 4.11156
R1870 Von.n180 Von.t34 4.11156
R1871 Von.n183 Von.t125 4.11156
R1872 Von.n187 Von.t121 4.11156
R1873 Von.n189 Von.t62 4.11156
R1874 Von.n126 Von.t113 4.1098
R1875 Von.n179 Von.t128 4.1098
R1876 Von.n214 Von.t124 4.1098
R1877 Von.n177 Von.t44 4.1098
R1878 Von.n163 Von.t78 4.1098
R1879 Von.n166 Von.t41 4.1098
R1880 Von.n160 Von.t103 4.1098
R1881 Von.n150 Von.t92 4.1098
R1882 Von.n148 Von.t153 4.1098
R1883 Von.n138 Von.t147 4.1098
R1884 Von.n136 Von.t68 4.1098
R1885 Von.n130 Von.t57 4.1098
R1886 Von.n132 Von.t115 4.1098
R1887 Von.n142 Von.t144 4.1098
R1888 Von.n144 Von.t154 4.1098
R1889 Von.n154 Von.t87 4.1098
R1890 Von.n156 Von.t85 4.1098
R1891 Von.n170 Von.t74 4.1098
R1892 Von.n173 Von.t79 4.1098
R1893 Von.n219 Von.t45 4.1098
R1894 Von.n175 Von.t134 4.1098
R1895 Von.n209 Von.t63 4.1098
R1896 Von.n200 Von.t64 4.1098
R1897 Von.n197 Von.t133 4.1098
R1898 Von.n14 Von.t46 4.1098
R1899 Von.n225 Von.t97 4.1098
R1900 Von.n31 Von.t75 4.1098
R1901 Von.n34 Von.t86 4.1098
R1902 Von.n37 Von.t88 4.1098
R1903 Von.n40 Von.t148 4.1098
R1904 Von.n43 Von.t145 4.1098
R1905 Von.n46 Von.t116 4.1098
R1906 Von.n49 Von.t55 4.1098
R1907 Von.n73 Von.t33 4.1098
R1908 Von.n77 Von.t80 4.1098
R1909 Von.n81 Von.t100 4.1098
R1910 Von.n85 Von.t143 4.1098
R1911 Von.n89 Von.t89 4.1098
R1912 Von.n91 Von.t102 4.1098
R1913 Von.n231 Von.t69 4.1098
R1914 Von.n11 Von.t42 4.1098
R1915 Von.n182 Von.t47 4.1098
R1916 Von.n186 Von.t131 4.1098
R1917 Von.n190 Von.t129 4.1098
R1918 Von.n248 Von.t130 4.1098
R1919 Von.n245 Von.t122 4.1098
R1920 Von.n242 Von.t50 4.1098
R1921 Von.n239 Von.t43 4.1098
R1922 Von.n236 Von.t70 4.1098
R1923 Von.n110 Von.t107 4.1098
R1924 Von.n108 Von.t146 4.1098
R1925 Von.n105 Von.t90 4.1098
R1926 Von.n102 Von.t101 4.1098
R1927 Von.n99 Von.t56 4.1098
R1928 Von.n96 Von.t32 4.1098
R1929 Von.n140 Von.n139 3.402
R1930 Von.n147 Von.n146 3.402
R1931 Von.n152 Von.n151 3.402
R1932 Von.n159 Von.n158 3.402
R1933 Von.n168 Von.n167 3.402
R1934 Von.n164 Von.n12 3.402
R1935 Von.n221 Von.n16 3.402
R1936 Von.n216 Von.n215 3.402
R1937 Von.n135 Von.n134 3.402
R1938 Von.n212 Von.n211 3.402
R1939 Von.n128 Von.n127 3.402
R1940 Von.n206 Von.n205 3.402
R1941 Von.n134 Von.n133 3.0005
R1942 Von.n141 Von.n140 3.0005
R1943 Von.n146 Von.n145 3.0005
R1944 Von.n153 Von.n152 3.0005
R1945 Von.n158 Von.n157 3.0005
R1946 Von.n169 Von.n168 3.0005
R1947 Von.n172 Von.n12 3.0005
R1948 Von.n221 Von.n220 3.0005
R1949 Von.n217 Von.n216 3.0005
R1950 Von.n211 Von.n210 3.0005
R1951 Von.n199 Von.n193 3.0005
R1952 Von.n196 Von.n176 3.0005
R1953 Von.n223 Von.n222 3.0005
R1954 Von.n227 Von.n226 3.0005
R1955 Von.n32 Von.n9 3.0005
R1956 Von.n35 Von.n19 3.0005
R1957 Von.n38 Von.n21 3.0005
R1958 Von.n41 Von.n23 3.0005
R1959 Von.n44 Von.n25 3.0005
R1960 Von.n47 Von.n27 3.0005
R1961 Von.n50 Von.n29 3.0005
R1962 Von.n129 Von.n128 3.0005
R1963 Von.n72 Von.n71 3.0005
R1964 Von.n76 Von.n75 3.0005
R1965 Von.n80 Von.n79 3.0005
R1966 Von.n84 Von.n83 3.0005
R1967 Von.n88 Von.n87 3.0005
R1968 Von.n93 Von.n92 3.0005
R1969 Von.n233 Von.n232 3.0005
R1970 Von.n229 Von.n228 3.0005
R1971 Von.n181 Von.n15 3.0005
R1972 Von.n185 Von.n184 3.0005
R1973 Von.n192 Von.n191 3.0005
R1974 Von.n188 Von.n7 3.0005
R1975 Von.n203 Von.n202 3.0005
R1976 Von.n207 Von.n206 3.0005
R1977 Von.n251 Von.n250 3.0005
R1978 Von.n247 Von.n5 3.0005
R1979 Von.n244 Von.n4 3.0005
R1980 Von.n241 Von.n3 3.0005
R1981 Von.n238 Von.n1 3.0005
R1982 Von.n235 Von.n234 3.0005
R1983 Von.n112 Von.n111 3.0005
R1984 Von.n107 Von.n69 3.0005
R1985 Von.n104 Von.n68 3.0005
R1986 Von.n101 Von.n57 3.0005
R1987 Von.n98 Von.n56 3.0005
R1988 Von.n95 Von.n55 3.0005
R1989 Von.n278 Von.n253 2.79264
R1990 Von.n284 Von.n283 2.79264
R1991 Von.n275 Von.n274 2.79264
R1992 Von.n262 Von.n261 2.79264
R1993 Von.n296 Von.n295 2.79261
R1994 Von.n259 Von.n258 2.79201
R1995 Von.n263 Von.n256 2.75434
R1996 Von.n299 Von.n298 2.754
R1997 Von.n292 Von.n291 2.75399
R1998 Von.n286 Von.n285 2.75399
R1999 Von.n272 Von.n271 2.75399
R2000 Von.n268 Von.n267 2.75399
R2001 Von.n269 Von.n256 2.70057
R2002 Von.n293 Von.n292 2.56786
R2003 Von.n285 Von.n252 2.56786
R2004 Von.n271 Von.n270 2.56786
R2005 Von.n269 Von.n268 2.56786
R2006 Von.n300 Von.n299 2.56783
R2007 Von.n67 Von.n66 2.28094
R2008 Von.n62 Von.n58 2.26567
R2009 Von.n65 Von.n64 2.2505
R2010 Von.n62 Von.n61 2.2505
R2011 Von.n60 Von.n59 2.2505
R2012 Von.n64 Von.n63 2.2505
R2013 Von.n279 Von.t1 2.04564
R2014 Von.n282 Von.t13 2.04564
R2015 Von.n276 Von.t29 2.04564
R2016 Von.n257 Von.t14 2.04564
R2017 Von.n260 Von.t7 2.04564
R2018 Von.n294 Von.t0 2.04293
R2019 Von.n295 Von.n294 1.22522
R2020 Von.n279 Von.n278 1.22501
R2021 Von.n283 Von.n282 1.22501
R2022 Von.n276 Von.n275 1.22501
R2023 Von.n261 Von.n260 1.22501
R2024 Von.n264 Von.n263 1.22501
R2025 Von.n298 Von.n297 1.22386
R2026 Von.n291 Von.n290 1.22386
R2027 Von.n287 Von.n286 1.22386
R2028 Von.n273 Von.n272 1.22386
R2029 Von.n267 Von.n266 1.22386
R2030 Von.n258 Von.n257 1.22386
R2031 Von.n266 Von.n259 1.22075
R2032 Von.n290 Von.n253 1.21996
R2033 Von.n287 Von.n284 1.21996
R2034 Von.n274 Von.n273 1.21996
R2035 Von.n264 Von.n262 1.21996
R2036 Von.n297 Von.n296 1.21972
R2037 Von.n66 Von.n65 1.15554
R2038 Von.n116 Von.n67 1.11866
R2039 Von.n116 Von.n58 1.11866
R2040 Von.n204 Von.n179 1.04934
R2041 Von.n214 Von.n213 1.04934
R2042 Von.n178 Von.n177 1.04934
R2043 Von.n163 Von.n162 1.04934
R2044 Von.n166 Von.n165 1.04934
R2045 Von.n161 Von.n160 1.04934
R2046 Von.n150 Von.n18 1.04934
R2047 Von.n149 Von.n148 1.04934
R2048 Von.n138 Von.n22 1.04934
R2049 Von.n137 Von.n136 1.04934
R2050 Von.n209 Von.n208 1.04934
R2051 Von.n201 Von.n200 1.04934
R2052 Von.n198 Von.n197 1.04934
R2053 Von.n195 Von.n14 1.04934
R2054 Von.n225 Von.n224 1.04934
R2055 Von.n31 Von.n13 1.04934
R2056 Von.n34 Von.n33 1.04934
R2057 Von.n37 Von.n36 1.04934
R2058 Von.n40 Von.n39 1.04934
R2059 Von.n43 Von.n42 1.04934
R2060 Von.n46 Von.n45 1.04934
R2061 Von.n49 Von.n48 1.04934
R2062 Von.n249 Von.n248 1.04934
R2063 Von.n246 Von.n245 1.04934
R2064 Von.n243 Von.n242 1.04934
R2065 Von.n240 Von.n239 1.04934
R2066 Von.n237 Von.n236 1.04934
R2067 Von.n110 Von.n8 1.04934
R2068 Von.n109 Von.n108 1.04934
R2069 Von.n106 Von.n105 1.04934
R2070 Von.n103 Von.n102 1.04934
R2071 Von.n100 Von.n99 1.04934
R2072 Von.n97 Von.n96 1.04934
R2073 Von.n126 Von.n26 1.04921
R2074 Von.n131 Von.n130 1.04921
R2075 Von.n132 Von.n24 1.04921
R2076 Von.n143 Von.n142 1.04921
R2077 Von.n144 Von.n20 1.04921
R2078 Von.n155 Von.n154 1.04921
R2079 Von.n156 Von.n17 1.04921
R2080 Von.n171 Von.n170 1.04921
R2081 Von.n174 Von.n173 1.04921
R2082 Von.n219 Von.n218 1.04921
R2083 Von.n194 Von.n175 1.04921
R2084 Von.n74 Von.n73 1.04921
R2085 Von.n78 Von.n77 1.04921
R2086 Von.n82 Von.n81 1.04921
R2087 Von.n86 Von.n85 1.04921
R2088 Von.n90 Von.n89 1.04921
R2089 Von.n91 Von.n10 1.04921
R2090 Von.n231 Von.n230 1.04921
R2091 Von.n180 Von.n11 1.04921
R2092 Von.n183 Von.n182 1.04921
R2093 Von.n187 Von.n186 1.04921
R2094 Von.n190 Von.n189 1.04921
R2095 Von.n94 Von.n54 1.00584
R2096 Von.n52 Von.n51 1.00558
R2097 Von.n125 Von.n124 1.00558
R2098 Von.n30 Von.n28 1.00558
R2099 Von.n70 Von.n53 1.00558
R2100 Von.n265 Von.n264 0.967195
R2101 Von.n260 Von.n255 0.967195
R2102 Von.n273 Von.n254 0.9005
R2103 Von.n288 Von.n287 0.9005
R2104 Von.n290 Von.n289 0.9005
R2105 Von.n297 Von.n6 0.9005
R2106 Von.n266 Von.n265 0.9005
R2107 Von.n257 Von.n255 0.9005
R2108 Von.n277 Von.n276 0.9005
R2109 Von.n282 Von.n281 0.9005
R2110 Von.n280 Von.n279 0.9005
R2111 Von.n294 Von.n2 0.9005
R2112 Von.n256 Von.t28 0.863268
R2113 Von.n292 Von.t12 0.862916
R2114 Von.n285 Von.t8 0.862916
R2115 Von.n271 Von.t9 0.862916
R2116 Von.n268 Von.t20 0.862916
R2117 Von.n299 Von.t16 0.862889
R2118 Von.n296 Von.t18 0.826406
R2119 Von.n295 Von.t27 0.826302
R2120 Von.n253 Von.t19 0.82619
R2121 Von.n284 Von.t10 0.82619
R2122 Von.n274 Von.t11 0.82619
R2123 Von.n262 Von.t23 0.82619
R2124 Von.n278 Von.t24 0.826088
R2125 Von.n283 Von.t25 0.826088
R2126 Von.n275 Von.t21 0.826088
R2127 Von.n261 Von.t2 0.826088
R2128 Von.n263 Von.t26 0.826088
R2129 Von.n298 Von.t5 0.825668
R2130 Von.n291 Von.t6 0.825668
R2131 Von.n286 Von.t17 0.825668
R2132 Von.n272 Von.t3 0.825668
R2133 Von.n267 Von.t4 0.825668
R2134 Von.n258 Von.t15 0.825668
R2135 Von.n259 Von.t22 0.825637
R2136 Von.n121 Von.n120 0.612309
R2137 Von.n122 Von.n121 0.612309
R2138 Von.n123 Von.n122 0.612309
R2139 Von.n120 Von.n119 0.534073
R2140 Von.n127 Von.n126 0.479315
R2141 Von.n212 Von.n179 0.479315
R2142 Von.n215 Von.n214 0.479315
R2143 Von.n177 Von.n16 0.479315
R2144 Von.n164 Von.n163 0.479315
R2145 Von.n167 Von.n166 0.479315
R2146 Von.n160 Von.n159 0.479315
R2147 Von.n151 Von.n150 0.479315
R2148 Von.n148 Von.n147 0.479315
R2149 Von.n139 Von.n138 0.479315
R2150 Von.n136 Von.n135 0.479315
R2151 Von.n130 Von.n129 0.479315
R2152 Von.n133 Von.n132 0.479315
R2153 Von.n142 Von.n141 0.479315
R2154 Von.n145 Von.n144 0.479315
R2155 Von.n154 Von.n153 0.479315
R2156 Von.n157 Von.n156 0.479315
R2157 Von.n170 Von.n169 0.479315
R2158 Von.n173 Von.n172 0.479315
R2159 Von.n220 Von.n219 0.479315
R2160 Von.n217 Von.n175 0.479315
R2161 Von.n210 Von.n209 0.479315
R2162 Von.n200 Von.n199 0.479315
R2163 Von.n197 Von.n196 0.479315
R2164 Von.n223 Von.n14 0.479315
R2165 Von.n226 Von.n225 0.479315
R2166 Von.n32 Von.n31 0.479315
R2167 Von.n35 Von.n34 0.479315
R2168 Von.n38 Von.n37 0.479315
R2169 Von.n41 Von.n40 0.479315
R2170 Von.n44 Von.n43 0.479315
R2171 Von.n47 Von.n46 0.479315
R2172 Von.n50 Von.n49 0.479315
R2173 Von.n73 Von.n72 0.479315
R2174 Von.n77 Von.n76 0.479315
R2175 Von.n81 Von.n80 0.479315
R2176 Von.n85 Von.n84 0.479315
R2177 Von.n89 Von.n88 0.479315
R2178 Von.n92 Von.n91 0.479315
R2179 Von.n232 Von.n231 0.479315
R2180 Von.n229 Von.n11 0.479315
R2181 Von.n182 Von.n181 0.479315
R2182 Von.n186 Von.n185 0.479315
R2183 Von.n191 Von.n190 0.479315
R2184 Von.n248 Von.n247 0.479315
R2185 Von.n245 Von.n244 0.479315
R2186 Von.n242 Von.n241 0.479315
R2187 Von.n239 Von.n238 0.479315
R2188 Von.n236 Von.n235 0.479315
R2189 Von.n111 Von.n110 0.479315
R2190 Von.n108 Von.n107 0.479315
R2191 Von.n105 Von.n104 0.479315
R2192 Von.n102 Von.n101 0.479315
R2193 Von.n99 Von.n98 0.479315
R2194 Von.n96 Von.n95 0.479315
R2195 Von.n51 Von.n50 0.439086
R2196 Von.n127 Von.n125 0.439086
R2197 Von.n135 Von.n26 0.439086
R2198 Von.n129 Von.n28 0.439086
R2199 Von.n133 Von.n131 0.439086
R2200 Von.n141 Von.n24 0.439086
R2201 Von.n145 Von.n143 0.439086
R2202 Von.n153 Von.n20 0.439086
R2203 Von.n157 Von.n155 0.439086
R2204 Von.n169 Von.n17 0.439086
R2205 Von.n172 Von.n171 0.439086
R2206 Von.n220 Von.n174 0.439086
R2207 Von.n218 Von.n217 0.439086
R2208 Von.n210 Von.n194 0.439086
R2209 Von.n72 Von.n70 0.439086
R2210 Von.n76 Von.n74 0.439086
R2211 Von.n80 Von.n78 0.439086
R2212 Von.n84 Von.n82 0.439086
R2213 Von.n88 Von.n86 0.439086
R2214 Von.n92 Von.n90 0.439086
R2215 Von.n232 Von.n10 0.439086
R2216 Von.n230 Von.n229 0.439086
R2217 Von.n181 Von.n180 0.439086
R2218 Von.n185 Von.n183 0.439086
R2219 Von.n191 Von.n187 0.439086
R2220 Von.n189 Von.n188 0.439086
R2221 Von.n205 Von.n204 0.438949
R2222 Von.n213 Von.n212 0.438949
R2223 Von.n215 Von.n178 0.438949
R2224 Von.n162 Von.n16 0.438949
R2225 Von.n165 Von.n164 0.438949
R2226 Von.n167 Von.n161 0.438949
R2227 Von.n159 Von.n18 0.438949
R2228 Von.n151 Von.n149 0.438949
R2229 Von.n147 Von.n22 0.438949
R2230 Von.n139 Von.n137 0.438949
R2231 Von.n208 Von.n207 0.438949
R2232 Von.n202 Von.n201 0.438949
R2233 Von.n199 Von.n198 0.438949
R2234 Von.n196 Von.n195 0.438949
R2235 Von.n224 Von.n223 0.438949
R2236 Von.n226 Von.n13 0.438949
R2237 Von.n33 Von.n32 0.438949
R2238 Von.n36 Von.n35 0.438949
R2239 Von.n39 Von.n38 0.438949
R2240 Von.n42 Von.n41 0.438949
R2241 Von.n45 Von.n44 0.438949
R2242 Von.n48 Von.n47 0.438949
R2243 Von.n250 Von.n249 0.438949
R2244 Von.n247 Von.n246 0.438949
R2245 Von.n244 Von.n243 0.438949
R2246 Von.n241 Von.n240 0.438949
R2247 Von.n238 Von.n237 0.438949
R2248 Von.n235 Von.n8 0.438949
R2249 Von.n111 Von.n109 0.438949
R2250 Von.n107 Von.n106 0.438949
R2251 Von.n104 Von.n103 0.438949
R2252 Von.n101 Von.n100 0.438949
R2253 Von.n98 Von.n97 0.438949
R2254 Von.n95 Von.n94 0.438949
R2255 Von.n79 Von.n57 0.402
R2256 Von.n79 Von.n25 0.402
R2257 Von.n140 Von.n25 0.402
R2258 Von.n83 Von.n68 0.402
R2259 Von.n83 Von.n23 0.402
R2260 Von.n146 Von.n23 0.402
R2261 Von.n87 Von.n69 0.402
R2262 Von.n87 Von.n21 0.402
R2263 Von.n152 Von.n21 0.402
R2264 Von.n112 Von.n93 0.402
R2265 Von.n93 Von.n19 0.402
R2266 Von.n158 Von.n19 0.402
R2267 Von.n234 Von.n233 0.402
R2268 Von.n233 Von.n9 0.402
R2269 Von.n168 Von.n9 0.402
R2270 Von.n228 Von.n1 0.402
R2271 Von.n228 Von.n227 0.402
R2272 Von.n227 Von.n12 0.402
R2273 Von.n15 Von.n3 0.402
R2274 Von.n222 Von.n15 0.402
R2275 Von.n222 Von.n221 0.402
R2276 Von.n184 Von.n4 0.402
R2277 Von.n184 Von.n176 0.402
R2278 Von.n216 Von.n176 0.402
R2279 Von.n75 Von.n56 0.402
R2280 Von.n75 Von.n27 0.402
R2281 Von.n134 Von.n27 0.402
R2282 Von.n192 Von.n5 0.402
R2283 Von.n193 Von.n192 0.402
R2284 Von.n211 Von.n193 0.402
R2285 Von.n71 Von.n55 0.402
R2286 Von.n71 Von.n29 0.402
R2287 Von.n128 Von.n29 0.402
R2288 Von.n251 Von.n7 0.402
R2289 Von.n203 Von.n7 0.402
R2290 Von.n206 Von.n203 0.402
R2291 Von.n117 Von.n57 0.3085
R2292 Von.n115 Von.n68 0.3085
R2293 Von.n114 Von.n69 0.3085
R2294 Von.n113 Von.n112 0.3085
R2295 Von.n234 Von.n0 0.3085
R2296 Von.n307 Von.n1 0.3085
R2297 Von.n305 Von.n3 0.3085
R2298 Von.n304 Von.n4 0.3085
R2299 Von.n118 Von.n56 0.3085
R2300 Von.n303 Von.n5 0.3085
R2301 Von.n119 Von.n55 0.3085
R2302 Von.n301 Von.n251 0.3085
R2303 Von.n301 Von.n300 0.215023
R2304 Von.n61 Von.t155 0.188525
R2305 Von Von.n310 0.178664
R2306 Von.n270 Von.n269 0.133889
R2307 Von.n270 Von.n252 0.133889
R2308 Von.n293 Von.n252 0.133889
R2309 Von.n300 Von.n293 0.133889
R2310 Von.n119 Von.n118 0.07002
R2311 Von.n118 Von.n117 0.07002
R2312 Von.n115 Von.n114 0.07002
R2313 Von.n114 Von.n113 0.07002
R2314 Von.n113 Von.n0 0.07002
R2315 Von.n305 Von.n304 0.07002
R2316 Von.n304 Von.n303 0.07002
R2317 Von.n303 Von.n302 0.06914
R2318 Von.n265 Von.n254 0.0671947
R2319 Von.n288 Von.n254 0.0671947
R2320 Von.n289 Von.n288 0.0671947
R2321 Von.n289 Von.n6 0.0671947
R2322 Von.n277 Von.n255 0.0671947
R2323 Von.n281 Von.n277 0.0671947
R2324 Von.n281 Von.n280 0.0671947
R2325 Von.n280 Von.n2 0.0671947
R2326 Von.n307 Von.n306 0.05726
R2327 Von.n308 Von.n0 0.04373
R2328 Von.n117 Von.n116 0.04351
R2329 Von.n65 Von.n61 0.0300385
R2330 Von.n64 Von.n62 0.0300385
R2331 Von.n64 Von.n60 0.0300385
R2332 Von.n63 Von.n59 0.0300385
R2333 Von.n116 Von.n115 0.02701
R2334 Von.n308 Von.n307 0.02679
R2335 Von.n63 Von.n58 0.0156729
R2336 Von.n67 Von.n59 0.0156729
R2337 Von.n66 Von.n60 0.0155778
R2338 Von.n306 Von.n305 0.01326
R2339 Von.n302 Von.n6 0.00953158
R2340 Von.n306 Von.n2 0.00953158
R2341 Von.n302 Von.n301 0.00138
R2342 VDD.t80 VDD.n674 17.0005
R2343 VDD.n677 VDD.t79 17.0005
R2344 VDD.t71 VDD.n649 17.0005
R2345 VDD.n673 VDD.t71 17.0005
R2346 VDD.t82 VDD.n732 17.0005
R2347 VDD.n735 VDD.t81 17.0005
R2348 VDD.t73 VDD.n707 17.0005
R2349 VDD.n731 VDD.t73 17.0005
R2350 VDD.t84 VDD.n790 17.0005
R2351 VDD.n793 VDD.t83 17.0005
R2352 VDD.t75 VDD.n765 17.0005
R2353 VDD.n789 VDD.t75 17.0005
R2354 VDD.n606 VDD.n596 17.0005
R2355 VDD.n833 VDD.n830 17.0005
R2356 VDD.n374 VDD.n373 17.0005
R2357 VDD.n558 VDD.t607 17.0005
R2358 VDD.t606 VDD.n556 17.0005
R2359 VDD.n560 VDD.t598 17.0005
R2360 VDD.t598 VDD.n559 17.0005
R2361 VDD.n501 VDD.t609 17.0005
R2362 VDD.t608 VDD.n499 17.0005
R2363 VDD.n503 VDD.t600 17.0005
R2364 VDD.t600 VDD.n502 17.0005
R2365 VDD.n444 VDD.t611 17.0005
R2366 VDD.t610 VDD.n442 17.0005
R2367 VDD.n446 VDD.t602 17.0005
R2368 VDD.t602 VDD.n445 17.0005
R2369 VDD.n186 VDD.n185 9.24142
R2370 VDD.n343 VDD.n342 9.24142
R2371 VDD.n193 VDD.n192 9.0005
R2372 VDD.n200 VDD.n199 9.0005
R2373 VDD.n207 VDD.n206 9.0005
R2374 VDD.n214 VDD.n213 9.0005
R2375 VDD.n178 VDD.n177 9.0005
R2376 VDD.n225 VDD.n224 9.0005
R2377 VDD.n232 VDD.n231 9.0005
R2378 VDD.n240 VDD.n239 9.0005
R2379 VDD.n247 VDD.n246 9.0005
R2380 VDD.n254 VDD.n253 9.0005
R2381 VDD.n163 VDD.n162 9.0005
R2382 VDD.n259 VDD.n169 9.0005
R2383 VDD.n266 VDD.n265 9.0005
R2384 VDD.n273 VDD.n272 9.0005
R2385 VDD.n281 VDD.n280 9.0005
R2386 VDD.n288 VDD.n287 9.0005
R2387 VDD.n295 VDD.n294 9.0005
R2388 VDD.n155 VDD.n154 9.0005
R2389 VDD.n307 VDD.n306 9.0005
R2390 VDD.n314 VDD.n313 9.0005
R2391 VDD.n322 VDD.n321 9.0005
R2392 VDD.n329 VDD.n328 9.0005
R2393 VDD.n336 VDD.n335 9.0005
R2394 VDD.n257 VDD.t0 8.85063
R2395 VDD.t1 VDD.n1925 8.501
R2396 VDD.t1 VDD.n2226 8.501
R2397 VDD.t1 VDD.n1924 8.501
R2398 VDD.t1 VDD.n18 8.501
R2399 VDD.t80 VDD.n636 8.49691
R2400 VDD.t80 VDD.n638 8.49691
R2401 VDD.t80 VDD.n640 8.49691
R2402 VDD.t80 VDD.n641 8.49691
R2403 VDD.t80 VDD.n642 8.49691
R2404 VDD.t80 VDD.n643 8.49691
R2405 VDD.t80 VDD.n645 8.49691
R2406 VDD.t80 VDD.n647 8.49691
R2407 VDD.n675 VDD.t80 8.49691
R2408 VDD.t80 VDD.n622 8.49691
R2409 VDD.t79 VDD.n624 8.49691
R2410 VDD.t79 VDD.n625 8.49691
R2411 VDD.t79 VDD.n626 8.49691
R2412 VDD.t79 VDD.n627 8.49691
R2413 VDD.t79 VDD.n629 8.49691
R2414 VDD.t79 VDD.n631 8.49691
R2415 VDD.t79 VDD.n632 8.49691
R2416 VDD.t79 VDD.n633 8.49691
R2417 VDD.t79 VDD.n634 8.49691
R2418 VDD.t79 VDD.n676 8.49691
R2419 VDD.t72 VDD.n661 8.49691
R2420 VDD.t72 VDD.n663 8.49691
R2421 VDD.t72 VDD.n664 8.49691
R2422 VDD.t72 VDD.n665 8.49691
R2423 VDD.t72 VDD.n666 8.49691
R2424 VDD.t72 VDD.n668 8.49691
R2425 VDD.t72 VDD.n670 8.49691
R2426 VDD.t72 VDD.n671 8.49691
R2427 VDD.t72 VDD.n648 8.49691
R2428 VDD.t71 VDD.n650 8.49691
R2429 VDD.t71 VDD.n651 8.49691
R2430 VDD.t71 VDD.n653 8.49691
R2431 VDD.t71 VDD.n655 8.49691
R2432 VDD.t71 VDD.n656 8.49691
R2433 VDD.t71 VDD.n657 8.49691
R2434 VDD.t71 VDD.n658 8.49691
R2435 VDD.t71 VDD.n660 8.49691
R2436 VDD.t82 VDD.n694 8.49691
R2437 VDD.t82 VDD.n696 8.49691
R2438 VDD.t82 VDD.n698 8.49691
R2439 VDD.t82 VDD.n699 8.49691
R2440 VDD.t82 VDD.n700 8.49691
R2441 VDD.t82 VDD.n701 8.49691
R2442 VDD.t82 VDD.n703 8.49691
R2443 VDD.t82 VDD.n705 8.49691
R2444 VDD.n733 VDD.t82 8.49691
R2445 VDD.t82 VDD.n680 8.49691
R2446 VDD.t81 VDD.n682 8.49691
R2447 VDD.t81 VDD.n683 8.49691
R2448 VDD.t81 VDD.n684 8.49691
R2449 VDD.t81 VDD.n685 8.49691
R2450 VDD.t81 VDD.n687 8.49691
R2451 VDD.t81 VDD.n689 8.49691
R2452 VDD.t81 VDD.n690 8.49691
R2453 VDD.t81 VDD.n691 8.49691
R2454 VDD.t81 VDD.n692 8.49691
R2455 VDD.t81 VDD.n734 8.49691
R2456 VDD.t74 VDD.n719 8.49691
R2457 VDD.t74 VDD.n721 8.49691
R2458 VDD.t74 VDD.n722 8.49691
R2459 VDD.t74 VDD.n723 8.49691
R2460 VDD.t74 VDD.n724 8.49691
R2461 VDD.t74 VDD.n726 8.49691
R2462 VDD.t74 VDD.n728 8.49691
R2463 VDD.t74 VDD.n729 8.49691
R2464 VDD.t74 VDD.n706 8.49691
R2465 VDD.t73 VDD.n708 8.49691
R2466 VDD.t73 VDD.n709 8.49691
R2467 VDD.t73 VDD.n711 8.49691
R2468 VDD.t73 VDD.n713 8.49691
R2469 VDD.t73 VDD.n714 8.49691
R2470 VDD.t73 VDD.n715 8.49691
R2471 VDD.t73 VDD.n716 8.49691
R2472 VDD.t73 VDD.n718 8.49691
R2473 VDD.t84 VDD.n752 8.49691
R2474 VDD.t84 VDD.n754 8.49691
R2475 VDD.t84 VDD.n756 8.49691
R2476 VDD.t84 VDD.n757 8.49691
R2477 VDD.t84 VDD.n758 8.49691
R2478 VDD.t84 VDD.n759 8.49691
R2479 VDD.t84 VDD.n761 8.49691
R2480 VDD.t84 VDD.n763 8.49691
R2481 VDD.n791 VDD.t84 8.49691
R2482 VDD.t84 VDD.n738 8.49691
R2483 VDD.t83 VDD.n740 8.49691
R2484 VDD.t83 VDD.n741 8.49691
R2485 VDD.t83 VDD.n742 8.49691
R2486 VDD.t83 VDD.n743 8.49691
R2487 VDD.t83 VDD.n745 8.49691
R2488 VDD.t83 VDD.n747 8.49691
R2489 VDD.t83 VDD.n748 8.49691
R2490 VDD.t83 VDD.n749 8.49691
R2491 VDD.t83 VDD.n750 8.49691
R2492 VDD.t83 VDD.n792 8.49691
R2493 VDD.t76 VDD.n777 8.49691
R2494 VDD.t76 VDD.n779 8.49691
R2495 VDD.t76 VDD.n780 8.49691
R2496 VDD.t76 VDD.n781 8.49691
R2497 VDD.t76 VDD.n782 8.49691
R2498 VDD.t76 VDD.n784 8.49691
R2499 VDD.t76 VDD.n786 8.49691
R2500 VDD.t76 VDD.n787 8.49691
R2501 VDD.t76 VDD.n764 8.49691
R2502 VDD.t75 VDD.n766 8.49691
R2503 VDD.t75 VDD.n767 8.49691
R2504 VDD.t75 VDD.n769 8.49691
R2505 VDD.t75 VDD.n771 8.49691
R2506 VDD.t75 VDD.n772 8.49691
R2507 VDD.t75 VDD.n773 8.49691
R2508 VDD.t75 VDD.n774 8.49691
R2509 VDD.t75 VDD.n776 8.49691
R2510 VDD.n529 VDD.t607 8.49691
R2511 VDD.n533 VDD.t607 8.49691
R2512 VDD.n537 VDD.t607 8.49691
R2513 VDD.n539 VDD.t607 8.49691
R2514 VDD.n541 VDD.t607 8.49691
R2515 VDD.n543 VDD.t607 8.49691
R2516 VDD.n547 VDD.t607 8.49691
R2517 VDD.n551 VDD.t607 8.49691
R2518 VDD.n553 VDD.t607 8.49691
R2519 VDD.n555 VDD.t607 8.49691
R2520 VDD.t606 VDD.n530 8.49691
R2521 VDD.t606 VDD.n532 8.49691
R2522 VDD.t606 VDD.n534 8.49691
R2523 VDD.t606 VDD.n536 8.49691
R2524 VDD.t606 VDD.n540 8.49691
R2525 VDD.t606 VDD.n544 8.49691
R2526 VDD.t606 VDD.n546 8.49691
R2527 VDD.t606 VDD.n548 8.49691
R2528 VDD.t606 VDD.n550 8.49691
R2529 VDD.t606 VDD.n554 8.49691
R2530 VDD.t599 VDD.n506 8.49691
R2531 VDD.t599 VDD.n519 8.49691
R2532 VDD.t599 VDD.n520 8.49691
R2533 VDD.t599 VDD.n521 8.49691
R2534 VDD.t599 VDD.n522 8.49691
R2535 VDD.t599 VDD.n524 8.49691
R2536 VDD.t599 VDD.n526 8.49691
R2537 VDD.t599 VDD.n527 8.49691
R2538 VDD.n528 VDD.t599 8.49691
R2539 VDD.t598 VDD.n507 8.49691
R2540 VDD.t598 VDD.n508 8.49691
R2541 VDD.t598 VDD.n510 8.49691
R2542 VDD.t598 VDD.n512 8.49691
R2543 VDD.t598 VDD.n513 8.49691
R2544 VDD.t598 VDD.n514 8.49691
R2545 VDD.t598 VDD.n515 8.49691
R2546 VDD.t598 VDD.n517 8.49691
R2547 VDD.n472 VDD.t609 8.49691
R2548 VDD.n476 VDD.t609 8.49691
R2549 VDD.n480 VDD.t609 8.49691
R2550 VDD.n482 VDD.t609 8.49691
R2551 VDD.n484 VDD.t609 8.49691
R2552 VDD.n486 VDD.t609 8.49691
R2553 VDD.n490 VDD.t609 8.49691
R2554 VDD.n494 VDD.t609 8.49691
R2555 VDD.n496 VDD.t609 8.49691
R2556 VDD.n498 VDD.t609 8.49691
R2557 VDD.t608 VDD.n473 8.49691
R2558 VDD.t608 VDD.n475 8.49691
R2559 VDD.t608 VDD.n477 8.49691
R2560 VDD.t608 VDD.n479 8.49691
R2561 VDD.t608 VDD.n483 8.49691
R2562 VDD.t608 VDD.n487 8.49691
R2563 VDD.t608 VDD.n489 8.49691
R2564 VDD.t608 VDD.n491 8.49691
R2565 VDD.t608 VDD.n493 8.49691
R2566 VDD.t608 VDD.n497 8.49691
R2567 VDD.t601 VDD.n449 8.49691
R2568 VDD.t601 VDD.n462 8.49691
R2569 VDD.t601 VDD.n463 8.49691
R2570 VDD.t601 VDD.n464 8.49691
R2571 VDD.t601 VDD.n465 8.49691
R2572 VDD.t601 VDD.n467 8.49691
R2573 VDD.t601 VDD.n469 8.49691
R2574 VDD.t601 VDD.n470 8.49691
R2575 VDD.n471 VDD.t601 8.49691
R2576 VDD.t600 VDD.n450 8.49691
R2577 VDD.t600 VDD.n451 8.49691
R2578 VDD.t600 VDD.n453 8.49691
R2579 VDD.t600 VDD.n455 8.49691
R2580 VDD.t600 VDD.n456 8.49691
R2581 VDD.t600 VDD.n457 8.49691
R2582 VDD.t600 VDD.n458 8.49691
R2583 VDD.t600 VDD.n460 8.49691
R2584 VDD.n415 VDD.t611 8.49691
R2585 VDD.n419 VDD.t611 8.49691
R2586 VDD.n423 VDD.t611 8.49691
R2587 VDD.n425 VDD.t611 8.49691
R2588 VDD.n427 VDD.t611 8.49691
R2589 VDD.n429 VDD.t611 8.49691
R2590 VDD.n433 VDD.t611 8.49691
R2591 VDD.n437 VDD.t611 8.49691
R2592 VDD.n439 VDD.t611 8.49691
R2593 VDD.n441 VDD.t611 8.49691
R2594 VDD.t610 VDD.n416 8.49691
R2595 VDD.t610 VDD.n418 8.49691
R2596 VDD.t610 VDD.n420 8.49691
R2597 VDD.t610 VDD.n422 8.49691
R2598 VDD.t610 VDD.n426 8.49691
R2599 VDD.t610 VDD.n430 8.49691
R2600 VDD.t610 VDD.n432 8.49691
R2601 VDD.t610 VDD.n434 8.49691
R2602 VDD.t610 VDD.n436 8.49691
R2603 VDD.t610 VDD.n440 8.49691
R2604 VDD.t603 VDD.n392 8.49691
R2605 VDD.t603 VDD.n405 8.49691
R2606 VDD.t603 VDD.n406 8.49691
R2607 VDD.t603 VDD.n407 8.49691
R2608 VDD.t603 VDD.n408 8.49691
R2609 VDD.t603 VDD.n410 8.49691
R2610 VDD.t603 VDD.n412 8.49691
R2611 VDD.t603 VDD.n413 8.49691
R2612 VDD.n414 VDD.t603 8.49691
R2613 VDD.t602 VDD.n393 8.49691
R2614 VDD.t602 VDD.n394 8.49691
R2615 VDD.t602 VDD.n396 8.49691
R2616 VDD.t602 VDD.n398 8.49691
R2617 VDD.t602 VDD.n399 8.49691
R2618 VDD.t602 VDD.n400 8.49691
R2619 VDD.t602 VDD.n401 8.49691
R2620 VDD.t602 VDD.n403 8.49691
R2621 VDD.t80 VDD.n637 8.49685
R2622 VDD.t80 VDD.n639 8.49685
R2623 VDD.t80 VDD.n644 8.49685
R2624 VDD.t80 VDD.n646 8.49685
R2625 VDD.t79 VDD.n623 8.49685
R2626 VDD.t79 VDD.n628 8.49685
R2627 VDD.t79 VDD.n630 8.49685
R2628 VDD.t79 VDD.n635 8.49685
R2629 VDD.t72 VDD.n662 8.49685
R2630 VDD.t72 VDD.n667 8.49685
R2631 VDD.t72 VDD.n669 8.49685
R2632 VDD.t71 VDD.n652 8.49685
R2633 VDD.t71 VDD.n654 8.49685
R2634 VDD.t71 VDD.n659 8.49685
R2635 VDD.t82 VDD.n695 8.49685
R2636 VDD.t82 VDD.n697 8.49685
R2637 VDD.t82 VDD.n702 8.49685
R2638 VDD.t82 VDD.n704 8.49685
R2639 VDD.t81 VDD.n681 8.49685
R2640 VDD.t81 VDD.n686 8.49685
R2641 VDD.t81 VDD.n688 8.49685
R2642 VDD.t81 VDD.n693 8.49685
R2643 VDD.t74 VDD.n720 8.49685
R2644 VDD.t74 VDD.n725 8.49685
R2645 VDD.t74 VDD.n727 8.49685
R2646 VDD.t73 VDD.n710 8.49685
R2647 VDD.t73 VDD.n712 8.49685
R2648 VDD.t73 VDD.n717 8.49685
R2649 VDD.t84 VDD.n753 8.49685
R2650 VDD.t84 VDD.n755 8.49685
R2651 VDD.t84 VDD.n760 8.49685
R2652 VDD.t84 VDD.n762 8.49685
R2653 VDD.t83 VDD.n739 8.49685
R2654 VDD.t83 VDD.n744 8.49685
R2655 VDD.t83 VDD.n746 8.49685
R2656 VDD.t83 VDD.n751 8.49685
R2657 VDD.t76 VDD.n778 8.49685
R2658 VDD.t76 VDD.n783 8.49685
R2659 VDD.t76 VDD.n785 8.49685
R2660 VDD.t75 VDD.n768 8.49685
R2661 VDD.t75 VDD.n770 8.49685
R2662 VDD.t75 VDD.n775 8.49685
R2663 VDD.n531 VDD.t607 8.49685
R2664 VDD.n535 VDD.t607 8.49685
R2665 VDD.n545 VDD.t607 8.49685
R2666 VDD.n549 VDD.t607 8.49685
R2667 VDD.n557 VDD.t606 8.49685
R2668 VDD.t606 VDD.n538 8.49685
R2669 VDD.t606 VDD.n542 8.49685
R2670 VDD.t606 VDD.n552 8.49685
R2671 VDD.t599 VDD.n518 8.49685
R2672 VDD.t599 VDD.n523 8.49685
R2673 VDD.t599 VDD.n525 8.49685
R2674 VDD.t598 VDD.n509 8.49685
R2675 VDD.t598 VDD.n511 8.49685
R2676 VDD.t598 VDD.n516 8.49685
R2677 VDD.n474 VDD.t609 8.49685
R2678 VDD.n478 VDD.t609 8.49685
R2679 VDD.n488 VDD.t609 8.49685
R2680 VDD.n492 VDD.t609 8.49685
R2681 VDD.n500 VDD.t608 8.49685
R2682 VDD.t608 VDD.n481 8.49685
R2683 VDD.t608 VDD.n485 8.49685
R2684 VDD.t608 VDD.n495 8.49685
R2685 VDD.t601 VDD.n461 8.49685
R2686 VDD.t601 VDD.n466 8.49685
R2687 VDD.t601 VDD.n468 8.49685
R2688 VDD.t600 VDD.n452 8.49685
R2689 VDD.t600 VDD.n454 8.49685
R2690 VDD.t600 VDD.n459 8.49685
R2691 VDD.n417 VDD.t611 8.49685
R2692 VDD.n421 VDD.t611 8.49685
R2693 VDD.n431 VDD.t611 8.49685
R2694 VDD.n435 VDD.t611 8.49685
R2695 VDD.n443 VDD.t610 8.49685
R2696 VDD.t610 VDD.n424 8.49685
R2697 VDD.t610 VDD.n428 8.49685
R2698 VDD.t610 VDD.n438 8.49685
R2699 VDD.t603 VDD.n404 8.49685
R2700 VDD.t603 VDD.n409 8.49685
R2701 VDD.t603 VDD.n411 8.49685
R2702 VDD.t602 VDD.n395 8.49685
R2703 VDD.t602 VDD.n397 8.49685
R2704 VDD.t602 VDD.n402 8.49685
R2705 VDD.n606 VDD.n600 8.42355
R2706 VDD.n607 VDD.n606 8.42355
R2707 VDD.n606 VDD.n599 8.42355
R2708 VDD.n373 VDD.n365 8.42355
R2709 VDD.n373 VDD.n363 8.42355
R2710 VDD.n373 VDD.n372 8.42355
R2711 VDD.n2230 VDD.n16 8.36189
R2712 VDD.n19 VDD.n17 8.31934
R2713 VDD.n2223 VDD.n1926 8.31934
R2714 VDD.n337 VDD.t923 6.49272
R2715 VDD.n330 VDD.t940 6.49272
R2716 VDD.n323 VDD.t942 6.49272
R2717 VDD.n316 VDD.t944 6.49272
R2718 VDD.n308 VDD.t946 6.49272
R2719 VDD.n301 VDD.t948 6.49272
R2720 VDD.n149 VDD.t950 6.49272
R2721 VDD.n289 VDD.t952 6.49272
R2722 VDD.n282 VDD.t954 6.49272
R2723 VDD.n275 VDD.t956 6.49272
R2724 VDD.n267 VDD.t958 6.49272
R2725 VDD.n260 VDD.t960 6.49272
R2726 VDD.n164 VDD.t962 6.49272
R2727 VDD.n157 VDD.t964 6.49272
R2728 VDD.n248 VDD.t966 6.49272
R2729 VDD.n241 VDD.t968 6.49272
R2730 VDD.n234 VDD.t970 6.49272
R2731 VDD.n226 VDD.t972 6.49272
R2732 VDD.n219 VDD.t974 6.49272
R2733 VDD.n172 VDD.t976 6.49272
R2734 VDD.n208 VDD.t978 6.49272
R2735 VDD.n201 VDD.t980 6.49272
R2736 VDD.n194 VDD.t982 6.49272
R2737 VDD.n187 VDD.t984 6.49272
R2738 VDD.n180 VDD.t986 6.49272
R2739 VDD.n1933 VDD.n20 6.15094
R2740 VDD.n342 VDD.t658 6.07543
R2741 VDD.n335 VDD.t659 6.07543
R2742 VDD.n328 VDD.t661 6.07543
R2743 VDD.n321 VDD.t663 6.07543
R2744 VDD.n313 VDD.t665 6.07543
R2745 VDD.n306 VDD.t667 6.07543
R2746 VDD.n154 VDD.t669 6.07543
R2747 VDD.n294 VDD.t671 6.07543
R2748 VDD.n287 VDD.t673 6.07543
R2749 VDD.n280 VDD.t675 6.07543
R2750 VDD.n272 VDD.t677 6.07543
R2751 VDD.n265 VDD.t679 6.07543
R2752 VDD.n169 VDD.t681 6.07543
R2753 VDD.n162 VDD.t683 6.07543
R2754 VDD.n253 VDD.t685 6.07543
R2755 VDD.n246 VDD.t687 6.07543
R2756 VDD.n239 VDD.t689 6.07543
R2757 VDD.n231 VDD.t691 6.07543
R2758 VDD.n224 VDD.t693 6.07543
R2759 VDD.n177 VDD.t695 6.07543
R2760 VDD.n213 VDD.t697 6.07543
R2761 VDD.n206 VDD.t699 6.07543
R2762 VDD.n199 VDD.t701 6.07543
R2763 VDD.n192 VDD.t703 6.07543
R2764 VDD.n185 VDD.t705 6.07543
R2765 VDD.n840 VDD.n839 5.6005
R2766 VDD.n337 VDD.t656 5.56245
R2767 VDD.n338 VDD.t653 5.56245
R2768 VDD.n339 VDD.t801 5.56245
R2769 VDD.n340 VDD.t728 5.56245
R2770 VDD.n341 VDD.t651 5.56245
R2771 VDD.n330 VDD.t892 5.56245
R2772 VDD.n331 VDD.t654 5.56245
R2773 VDD.n332 VDD.t802 5.56245
R2774 VDD.n333 VDD.t754 5.56245
R2775 VDD.n334 VDD.t652 5.56245
R2776 VDD.n323 VDD.t894 5.56245
R2777 VDD.n324 VDD.t848 5.56245
R2778 VDD.n325 VDD.t804 5.56245
R2779 VDD.n326 VDD.t729 5.56245
R2780 VDD.n327 VDD.t707 5.56245
R2781 VDD.n316 VDD.t896 5.56245
R2782 VDD.n317 VDD.t655 5.56245
R2783 VDD.n318 VDD.t776 5.56245
R2784 VDD.n319 VDD.t757 5.56245
R2785 VDD.n320 VDD.t709 5.56245
R2786 VDD.n308 VDD.t898 5.56245
R2787 VDD.n309 VDD.t851 5.56245
R2788 VDD.n310 VDD.t807 5.56245
R2789 VDD.n311 VDD.t759 5.56245
R2790 VDD.n312 VDD.t711 5.56245
R2791 VDD.n301 VDD.t900 5.56245
R2792 VDD.n302 VDD.t853 5.56245
R2793 VDD.n303 VDD.t809 5.56245
R2794 VDD.n304 VDD.t761 5.56245
R2795 VDD.n305 VDD.t713 5.56245
R2796 VDD.n149 VDD.t902 5.56245
R2797 VDD.n150 VDD.t855 5.56245
R2798 VDD.n151 VDD.t811 5.56245
R2799 VDD.n152 VDD.t763 5.56245
R2800 VDD.n153 VDD.t715 5.56245
R2801 VDD.n289 VDD.t904 5.56245
R2802 VDD.n290 VDD.t857 5.56245
R2803 VDD.n291 VDD.t813 5.56245
R2804 VDD.n292 VDD.t765 5.56245
R2805 VDD.n293 VDD.t717 5.56245
R2806 VDD.n282 VDD.t906 5.56245
R2807 VDD.n283 VDD.t859 5.56245
R2808 VDD.n284 VDD.t815 5.56245
R2809 VDD.n285 VDD.t767 5.56245
R2810 VDD.n286 VDD.t719 5.56245
R2811 VDD.n275 VDD.t908 5.56245
R2812 VDD.n276 VDD.t861 5.56245
R2813 VDD.n277 VDD.t817 5.56245
R2814 VDD.n278 VDD.t769 5.56245
R2815 VDD.n279 VDD.t721 5.56245
R2816 VDD.n267 VDD.t910 5.56245
R2817 VDD.n268 VDD.t863 5.56245
R2818 VDD.n269 VDD.t819 5.56245
R2819 VDD.n270 VDD.t771 5.56245
R2820 VDD.n271 VDD.t723 5.56245
R2821 VDD.n260 VDD.t912 5.56245
R2822 VDD.n261 VDD.t865 5.56245
R2823 VDD.n262 VDD.t821 5.56245
R2824 VDD.n263 VDD.t773 5.56245
R2825 VDD.n264 VDD.t725 5.56245
R2826 VDD.n164 VDD.t914 5.56245
R2827 VDD.n165 VDD.t867 5.56245
R2828 VDD.n166 VDD.t823 5.56245
R2829 VDD.n167 VDD.t775 5.56245
R2830 VDD.n168 VDD.t727 5.56245
R2831 VDD.n157 VDD.t916 5.56245
R2832 VDD.n158 VDD.t869 5.56245
R2833 VDD.n159 VDD.t825 5.56245
R2834 VDD.n160 VDD.t778 5.56245
R2835 VDD.n161 VDD.t731 5.56245
R2836 VDD.n248 VDD.t918 5.56245
R2837 VDD.n249 VDD.t871 5.56245
R2838 VDD.n250 VDD.t827 5.56245
R2839 VDD.n251 VDD.t780 5.56245
R2840 VDD.n252 VDD.t733 5.56245
R2841 VDD.n241 VDD.t920 5.56245
R2842 VDD.n242 VDD.t873 5.56245
R2843 VDD.n243 VDD.t829 5.56245
R2844 VDD.n244 VDD.t782 5.56245
R2845 VDD.n245 VDD.t735 5.56245
R2846 VDD.n234 VDD.t922 5.56245
R2847 VDD.n235 VDD.t875 5.56245
R2848 VDD.n236 VDD.t831 5.56245
R2849 VDD.n237 VDD.t784 5.56245
R2850 VDD.n238 VDD.t737 5.56245
R2851 VDD.n226 VDD.t925 5.56245
R2852 VDD.n227 VDD.t877 5.56245
R2853 VDD.n228 VDD.t833 5.56245
R2854 VDD.n229 VDD.t786 5.56245
R2855 VDD.n230 VDD.t739 5.56245
R2856 VDD.n219 VDD.t927 5.56245
R2857 VDD.n220 VDD.t879 5.56245
R2858 VDD.n221 VDD.t835 5.56245
R2859 VDD.n222 VDD.t788 5.56245
R2860 VDD.n223 VDD.t741 5.56245
R2861 VDD.n172 VDD.t929 5.56245
R2862 VDD.n173 VDD.t881 5.56245
R2863 VDD.n174 VDD.t657 5.56245
R2864 VDD.n175 VDD.t790 5.56245
R2865 VDD.n176 VDD.t743 5.56245
R2866 VDD.n208 VDD.t931 5.56245
R2867 VDD.n209 VDD.t883 5.56245
R2868 VDD.n210 VDD.t838 5.56245
R2869 VDD.n211 VDD.t792 5.56245
R2870 VDD.n212 VDD.t745 5.56245
R2871 VDD.n201 VDD.t933 5.56245
R2872 VDD.n202 VDD.t885 5.56245
R2873 VDD.n203 VDD.t840 5.56245
R2874 VDD.n204 VDD.t794 5.56245
R2875 VDD.n205 VDD.t747 5.56245
R2876 VDD.n194 VDD.t935 5.56245
R2877 VDD.n195 VDD.t887 5.56245
R2878 VDD.n196 VDD.t842 5.56245
R2879 VDD.n197 VDD.t796 5.56245
R2880 VDD.n198 VDD.t749 5.56245
R2881 VDD.n187 VDD.t937 5.56245
R2882 VDD.n188 VDD.t889 5.56245
R2883 VDD.n189 VDD.t844 5.56245
R2884 VDD.n190 VDD.t798 5.56245
R2885 VDD.n191 VDD.t751 5.56245
R2886 VDD.n180 VDD.t939 5.56245
R2887 VDD.n181 VDD.t891 5.56245
R2888 VDD.n182 VDD.t846 5.56245
R2889 VDD.n183 VDD.t800 5.56245
R2890 VDD.n184 VDD.t753 5.56245
R2891 VDD.n606 VDD.n605 5.53155
R2892 VDD.n373 VDD.n367 5.53155
R2893 VDD.n831 VDD.t625 5.40803
R2894 VDD.n834 VDD.t632 5.40803
R2895 VDD.n2215 VDD.n2214 5.38649
R2896 VDD.n1091 VDD.n1090 5.38637
R2897 VDD.n1928 VDD.t32 5.18946
R2898 VDD.n1927 VDD.t31 5.18857
R2899 VDD.n1929 VDD.t34 5.18857
R2900 VDD.n829 VDD.n608 5.1005
R2901 VDD.n841 VDD.n375 5.1005
R2902 VDD.n1543 VDD.n1542 4.93126
R2903 VDD.n1568 VDD.n1567 4.93057
R2904 VDD.n1091 VDD.n866 4.77469
R2905 VDD.n1092 VDD.n865 4.77469
R2906 VDD.n1093 VDD.n864 4.77469
R2907 VDD.n1094 VDD.n863 4.77469
R2908 VDD.n1131 VDD.n1130 4.77469
R2909 VDD.n2218 VDD.n1938 4.77469
R2910 VDD.n2217 VDD.n1939 4.77469
R2911 VDD.n2216 VDD.n1940 4.77469
R2912 VDD.n2215 VDD.n1941 4.77469
R2913 VDD.n2219 VDD.n1937 4.77456
R2914 VDD.n1095 VDD.t356 4.55297
R2915 VDD.n891 VDD.t354 4.55297
R2916 VDD.n1017 VDD.t350 4.55297
R2917 VDD.n1022 VDD.t348 4.55297
R2918 VDD.n981 VDD.t352 4.55297
R2919 VDD.n1020 VDD.t347 4.55297
R2920 VDD.n1992 VDD.t104 4.55297
R2921 VDD.n2065 VDD.t100 4.55297
R2922 VDD.n2068 VDD.t96 4.55297
R2923 VDD.n2071 VDD.t98 4.55297
R2924 VDD.n1995 VDD.t102 4.55297
R2925 VDD.n1960 VDD.t95 4.55297
R2926 VDD.n1576 VDD.n1575 4.38818
R2927 VDD.n1544 VDD.n1521 4.38801
R2928 VDD.n1543 VDD.n1522 4.38801
R2929 VDD.n1568 VDD.n1547 4.38801
R2930 VDD.n1569 VDD.n1546 4.38801
R2931 VDD.n1545 VDD.n1520 4.38748
R2932 VDD.n1090 VDD.t587 4.15035
R2933 VDD.n1937 VDD.t335 4.15035
R2934 VDD.n866 VDD.t588 4.15023
R2935 VDD.n865 VDD.t590 4.15023
R2936 VDD.n864 VDD.t592 4.15023
R2937 VDD.n863 VDD.t594 4.15023
R2938 VDD.n1130 VDD.t596 4.15023
R2939 VDD.n1938 VDD.t336 4.15023
R2940 VDD.n1939 VDD.t338 4.15023
R2941 VDD.n1940 VDD.t340 4.15023
R2942 VDD.n1941 VDD.t342 4.15023
R2943 VDD.n2214 VDD.t344 4.15023
R2944 VDD.n1084 VDD.t568 4.11153
R2945 VDD.n985 VDD.t570 4.11153
R2946 VDD.n988 VDD.t550 4.11153
R2947 VDD.n991 VDD.t530 4.11153
R2948 VDD.n994 VDD.t510 4.11153
R2949 VDD.n997 VDD.t490 4.11153
R2950 VDD.n1000 VDD.t470 4.11153
R2951 VDD.n1003 VDD.t450 4.11153
R2952 VDD.n1006 VDD.t430 4.11153
R2953 VDD.n1009 VDD.t410 4.11153
R2954 VDD.n913 VDD.t574 4.11153
R2955 VDD.n925 VDD.t554 4.11153
R2956 VDD.n909 VDD.t534 4.11153
R2957 VDD.n937 VDD.t514 4.11153
R2958 VDD.n905 VDD.t494 4.11153
R2959 VDD.n949 VDD.t474 4.11153
R2960 VDD.n901 VDD.t454 4.11153
R2961 VDD.n961 VDD.t434 4.11153
R2962 VDD.n897 VDD.t414 4.11153
R2963 VDD.n973 VDD.t394 4.11153
R2964 VDD.n887 VDD.t367 4.11153
R2965 VDD.n1030 VDD.t387 4.11153
R2966 VDD.n883 VDD.t407 4.11153
R2967 VDD.n1042 VDD.t427 4.11153
R2968 VDD.n879 VDD.t447 4.11153
R2969 VDD.n1054 VDD.t467 4.11153
R2970 VDD.n875 VDD.t487 4.11153
R2971 VDD.n1066 VDD.t507 4.11153
R2972 VDD.n871 VDD.t527 4.11153
R2973 VDD.n1078 VDD.t547 4.11153
R2974 VDD.n867 VDD.t567 4.11153
R2975 VDD.n2182 VDD.t316 4.11153
R2976 VDD.n1953 VDD.t296 4.11153
R2977 VDD.n2113 VDD.t276 4.11153
R2978 VDD.n2110 VDD.t256 4.11153
R2979 VDD.n2125 VDD.t236 4.11153
R2980 VDD.n1976 VDD.t216 4.11153
R2981 VDD.n2137 VDD.t196 4.11153
R2982 VDD.n2140 VDD.t176 4.11153
R2983 VDD.n1970 VDD.t156 4.11153
R2984 VDD.n2188 VDD.t318 4.11153
R2985 VDD.n2201 VDD.t320 4.11153
R2986 VDD.n2198 VDD.t300 4.11153
R2987 VDD.n1948 VDD.t280 4.11153
R2988 VDD.n2106 VDD.t260 4.11153
R2989 VDD.n2103 VDD.t240 4.11153
R2990 VDD.n2100 VDD.t220 4.11153
R2991 VDD.n2097 VDD.t200 4.11153
R2992 VDD.n1982 VDD.t180 4.11153
R2993 VDD.n2057 VDD.t160 4.11153
R2994 VDD.n2060 VDD.t140 4.11153
R2995 VDD.n1962 VDD.t115 4.11153
R2996 VDD.n1965 VDD.t135 4.11153
R2997 VDD.n1968 VDD.t155 4.11153
R2998 VDD.n2147 VDD.t175 4.11153
R2999 VDD.n2159 VDD.t195 4.11153
R3000 VDD.n2156 VDD.t215 4.11153
R3001 VDD.n2153 VDD.t235 4.11153
R3002 VDD.n2150 VDD.t255 4.11153
R3003 VDD.n1954 VDD.t275 4.11153
R3004 VDD.n2172 VDD.t295 4.11153
R3005 VDD.n2175 VDD.t315 4.11153
R3006 VDD.n893 VDD.t374 4.11141
R3007 VDD.n1015 VDD.t370 4.11141
R3008 VDD.n1012 VDD.t390 4.11141
R3009 VDD.n1024 VDD.t368 4.11141
R3010 VDD.n885 VDD.t388 4.11141
R3011 VDD.n1036 VDD.t408 4.11141
R3012 VDD.n881 VDD.t428 4.11141
R3013 VDD.n1048 VDD.t448 4.11141
R3014 VDD.n877 VDD.t468 4.11141
R3015 VDD.n1060 VDD.t488 4.11141
R3016 VDD.n873 VDD.t508 4.11141
R3017 VDD.n1072 VDD.t528 4.11141
R3018 VDD.n869 VDD.t548 4.11141
R3019 VDD.n979 VDD.t372 4.11141
R3020 VDD.n895 VDD.t392 4.11141
R3021 VDD.n967 VDD.t412 4.11141
R3022 VDD.n899 VDD.t432 4.11141
R3023 VDD.n955 VDD.t452 4.11141
R3024 VDD.n903 VDD.t472 4.11141
R3025 VDD.n943 VDD.t492 4.11141
R3026 VDD.n907 VDD.t512 4.11141
R3027 VDD.n931 VDD.t532 4.11141
R3028 VDD.n911 VDD.t552 4.11141
R3029 VDD.n919 VDD.t572 4.11141
R3030 VDD.n1127 VDD.t576 4.11141
R3031 VDD.n1124 VDD.t556 4.11141
R3032 VDD.n1121 VDD.t536 4.11141
R3033 VDD.n1118 VDD.t516 4.11141
R3034 VDD.n1115 VDD.t496 4.11141
R3035 VDD.n1112 VDD.t476 4.11141
R3036 VDD.n1109 VDD.t456 4.11141
R3037 VDD.n1106 VDD.t436 4.11141
R3038 VDD.n1103 VDD.t416 4.11141
R3039 VDD.n1100 VDD.t396 4.11141
R3040 VDD.n1097 VDD.t376 4.11141
R3041 VDD.n2063 VDD.t120 4.11141
R3042 VDD.n1986 VDD.t116 4.11141
R3043 VDD.n2080 VDD.t136 4.11141
R3044 VDD.n2073 VDD.t118 4.11141
R3045 VDD.n1984 VDD.t138 4.11141
R3046 VDD.n2087 VDD.t158 4.11141
R3047 VDD.n2090 VDD.t178 4.11141
R3048 VDD.n1973 VDD.t198 4.11141
R3049 VDD.n2131 VDD.t218 4.11141
R3050 VDD.n1979 VDD.t238 4.11141
R3051 VDD.n2119 VDD.t258 4.11141
R3052 VDD.n1951 VDD.t278 4.11141
R3053 VDD.n2191 VDD.t298 4.11141
R3054 VDD.n1997 VDD.t122 4.11141
R3055 VDD.n1991 VDD.t142 4.11141
R3056 VDD.n2010 VDD.t162 4.11141
R3057 VDD.n2051 VDD.t182 4.11141
R3058 VDD.n2048 VDD.t202 4.11141
R3059 VDD.n2018 VDD.t222 4.11141
R3060 VDD.n2038 VDD.t242 4.11141
R3061 VDD.n2024 VDD.t262 4.11141
R3062 VDD.n2021 VDD.t282 4.11141
R3063 VDD.n1944 VDD.t302 4.11141
R3064 VDD.n2208 VDD.t322 4.11141
R3065 VDD.n1942 VDD.t324 4.11141
R3066 VDD.n2027 VDD.t304 4.11141
R3067 VDD.n2030 VDD.t284 4.11141
R3068 VDD.n2033 VDD.t264 4.11141
R3069 VDD.n2026 VDD.t244 4.11141
R3070 VDD.n2043 VDD.t224 4.11141
R3071 VDD.n2016 VDD.t204 4.11141
R3072 VDD.n2013 VDD.t184 4.11141
R3073 VDD.n2004 VDD.t164 4.11141
R3074 VDD.n2003 VDD.t144 4.11141
R3075 VDD.n1994 VDD.t124 4.11141
R3076 VDD.n1019 VDD.t357 4.11007
R3077 VDD.n1029 VDD.t377 4.11007
R3078 VDD.n1031 VDD.t397 4.11007
R3079 VDD.n1041 VDD.t417 4.11007
R3080 VDD.n1043 VDD.t437 4.11007
R3081 VDD.n1053 VDD.t457 4.11007
R3082 VDD.n1055 VDD.t477 4.11007
R3083 VDD.n1065 VDD.t497 4.11007
R3084 VDD.n1067 VDD.t517 4.11007
R3085 VDD.n1077 VDD.t537 4.11007
R3086 VDD.n1079 VDD.t557 4.11007
R3087 VDD.n1089 VDD.t577 4.11007
R3088 VDD.n1961 VDD.t105 4.11007
R3089 VDD.n1964 VDD.t125 4.11007
R3090 VDD.n1967 VDD.t145 4.11007
R3091 VDD.n2146 VDD.t165 4.11007
R3092 VDD.n2160 VDD.t185 4.11007
R3093 VDD.n2157 VDD.t205 4.11007
R3094 VDD.n2154 VDD.t225 4.11007
R3095 VDD.n2151 VDD.t245 4.11007
R3096 VDD.n2148 VDD.t265 4.11007
R3097 VDD.n2171 VDD.t285 4.11007
R3098 VDD.n2176 VDD.t305 4.11007
R3099 VDD.n2173 VDD.t325 4.11007
R3100 VDD.n892 VDD.t364 4.10995
R3101 VDD.n1016 VDD.t360 4.10995
R3102 VDD.n1013 VDD.t380 4.10995
R3103 VDD.n1023 VDD.t358 4.10995
R3104 VDD.n1025 VDD.t378 4.10995
R3105 VDD.n1035 VDD.t398 4.10995
R3106 VDD.n1037 VDD.t418 4.10995
R3107 VDD.n1047 VDD.t438 4.10995
R3108 VDD.n1049 VDD.t458 4.10995
R3109 VDD.n1059 VDD.t478 4.10995
R3110 VDD.n1061 VDD.t498 4.10995
R3111 VDD.n1071 VDD.t518 4.10995
R3112 VDD.n1073 VDD.t538 4.10995
R3113 VDD.n1085 VDD.t578 4.10995
R3114 VDD.n1083 VDD.t558 4.10995
R3115 VDD.n983 VDD.t580 4.10995
R3116 VDD.n986 VDD.t560 4.10995
R3117 VDD.n989 VDD.t540 4.10995
R3118 VDD.n992 VDD.t520 4.10995
R3119 VDD.n995 VDD.t500 4.10995
R3120 VDD.n998 VDD.t480 4.10995
R3121 VDD.n1001 VDD.t460 4.10995
R3122 VDD.n1004 VDD.t440 4.10995
R3123 VDD.n1007 VDD.t420 4.10995
R3124 VDD.n1010 VDD.t400 4.10995
R3125 VDD.n980 VDD.t362 4.10995
R3126 VDD.n890 VDD.t382 4.10995
R3127 VDD.n968 VDD.t402 4.10995
R3128 VDD.n896 VDD.t422 4.10995
R3129 VDD.n956 VDD.t442 4.10995
R3130 VDD.n900 VDD.t462 4.10995
R3131 VDD.n944 VDD.t482 4.10995
R3132 VDD.n904 VDD.t502 4.10995
R3133 VDD.n932 VDD.t522 4.10995
R3134 VDD.n908 VDD.t542 4.10995
R3135 VDD.n920 VDD.t562 4.10995
R3136 VDD.n912 VDD.t582 4.10995
R3137 VDD.n914 VDD.t584 4.10995
R3138 VDD.n910 VDD.t564 4.10995
R3139 VDD.n926 VDD.t544 4.10995
R3140 VDD.n906 VDD.t524 4.10995
R3141 VDD.n938 VDD.t504 4.10995
R3142 VDD.n902 VDD.t484 4.10995
R3143 VDD.n950 VDD.t464 4.10995
R3144 VDD.n898 VDD.t444 4.10995
R3145 VDD.n962 VDD.t424 4.10995
R3146 VDD.n894 VDD.t404 4.10995
R3147 VDD.n974 VDD.t384 4.10995
R3148 VDD.n1129 VDD.t586 4.10995
R3149 VDD.n1126 VDD.t566 4.10995
R3150 VDD.n1123 VDD.t546 4.10995
R3151 VDD.n1120 VDD.t526 4.10995
R3152 VDD.n1117 VDD.t506 4.10995
R3153 VDD.n1114 VDD.t486 4.10995
R3154 VDD.n1111 VDD.t466 4.10995
R3155 VDD.n1108 VDD.t446 4.10995
R3156 VDD.n1105 VDD.t426 4.10995
R3157 VDD.n1102 VDD.t406 4.10995
R3158 VDD.n1099 VDD.t386 4.10995
R3159 VDD.n1096 VDD.t366 4.10995
R3160 VDD.n2064 VDD.t110 4.10995
R3161 VDD.n2067 VDD.t106 4.10995
R3162 VDD.n2079 VDD.t126 4.10995
R3163 VDD.n2183 VDD.t326 4.10995
R3164 VDD.n2181 VDD.t306 4.10995
R3165 VDD.n2111 VDD.t286 4.10995
R3166 VDD.n2114 VDD.t266 4.10995
R3167 VDD.n1977 VDD.t246 4.10995
R3168 VDD.n2126 VDD.t226 4.10995
R3169 VDD.n1971 VDD.t206 4.10995
R3170 VDD.n2138 VDD.t186 4.10995
R3171 VDD.n2141 VDD.t166 4.10995
R3172 VDD.n2081 VDD.t146 4.10995
R3173 VDD.n2072 VDD.t108 4.10995
R3174 VDD.n2074 VDD.t128 4.10995
R3175 VDD.n2086 VDD.t148 4.10995
R3176 VDD.n2089 VDD.t168 4.10995
R3177 VDD.n2091 VDD.t188 4.10995
R3178 VDD.n2132 VDD.t208 4.10995
R3179 VDD.n1974 VDD.t228 4.10995
R3180 VDD.n2120 VDD.t248 4.10995
R3181 VDD.n1980 VDD.t268 4.10995
R3182 VDD.n2192 VDD.t288 4.10995
R3183 VDD.n1952 VDD.t328 4.10995
R3184 VDD.n2189 VDD.t308 4.10995
R3185 VDD.n2199 VDD.t330 4.10995
R3186 VDD.n2202 VDD.t310 4.10995
R3187 VDD.n2197 VDD.t290 4.10995
R3188 VDD.n2107 VDD.t270 4.10995
R3189 VDD.n2105 VDD.t250 4.10995
R3190 VDD.n2102 VDD.t230 4.10995
R3191 VDD.n2099 VDD.t210 4.10995
R3192 VDD.n2096 VDD.t190 4.10995
R3193 VDD.n1989 VDD.t170 4.10995
R3194 VDD.n2058 VDD.t150 4.10995
R3195 VDD.n2061 VDD.t130 4.10995
R3196 VDD.n1996 VDD.t112 4.10995
R3197 VDD.n1998 VDD.t132 4.10995
R3198 VDD.n2009 VDD.t152 4.10995
R3199 VDD.n2052 VDD.t172 4.10995
R3200 VDD.n2049 VDD.t192 4.10995
R3201 VDD.n2011 VDD.t212 4.10995
R3202 VDD.n2039 VDD.t232 4.10995
R3203 VDD.n2025 VDD.t252 4.10995
R3204 VDD.n2022 VDD.t272 4.10995
R3205 VDD.n2019 VDD.t292 4.10995
R3206 VDD.n2207 VDD.t312 4.10995
R3207 VDD.n2209 VDD.t332 4.10995
R3208 VDD.n2213 VDD.t334 4.10995
R3209 VDD.n1945 VDD.t314 4.10995
R3210 VDD.n2028 VDD.t294 4.10995
R3211 VDD.n2031 VDD.t274 4.10995
R3212 VDD.n2034 VDD.t254 4.10995
R3213 VDD.n2017 VDD.t234 4.10995
R3214 VDD.n2044 VDD.t214 4.10995
R3215 VDD.n2015 VDD.t194 4.10995
R3216 VDD.n2012 VDD.t174 4.10995
R3217 VDD.n2005 VDD.t154 4.10995
R3218 VDD.n2002 VDD.t134 4.10995
R3219 VDD.n1993 VDD.t114 4.10995
R3220 VDD.n1927 VDD.t27 4.09798
R3221 VDD.n1929 VDD.t30 4.09798
R3222 VDD.n1928 VDD.t28 4.09785
R3223 VDD.n1930 VDD.t345 4.0075
R3224 VDD.n2229 VDD.n17 3.85876
R3225 VDD.n837 VDD.n836 3.57525
R3226 VDD.n1540 VDD.n1539 3.54359
R3227 VDD.n1565 VDD.n1564 3.54359
R3228 VDD.n1558 VDD.n1557 3.54359
R3229 VDD.n1533 VDD.n1526 3.54359
R3230 VDD.n1660 VDD.n22 3.51592
R3231 VDD.n1190 VDD.n25 3.51592
R3232 VDD.n1530 VDD.n1529 3.50228
R3233 VDD.n1536 VDD.n1535 3.50228
R3234 VDD.n1525 VDD.n1523 3.50228
R3235 VDD.n1561 VDD.n1560 3.50228
R3236 VDD.n1553 VDD.n1552 3.50228
R3237 VDD.n1572 VDD.n1571 3.50228
R3238 VDD.n1517 VDD.n1516 3.50223
R3239 VDD.n1556 VDD.n1548 3.50223
R3240 VDD.n1520 VDD.n1519 3.49227
R3241 VDD.n1567 VDD.n1566 3.49227
R3242 VDD.n1527 VDD.n1521 3.49195
R3243 VDD.n1537 VDD.n1522 3.49195
R3244 VDD.n1562 VDD.n1547 3.49195
R3245 VDD.n1550 VDD.n1546 3.49195
R3246 VDD.n1542 VDD.n1541 3.49172
R3247 VDD.n1575 VDD.n1574 3.49172
R3248 VDD.n1133 VDD.n27 3.47754
R3249 VDD.n1143 VDD.n27 3.46986
R3250 VDD.n2230 VDD.n2229 3.41918
R3251 VDD.n672 VDD.t72 3.4022
R3252 VDD.n730 VDD.t74 3.4022
R3253 VDD.n788 VDD.t76 3.4022
R3254 VDD.t599 VDD.n505 3.4022
R3255 VDD.t601 VDD.n448 3.4022
R3256 VDD.t603 VDD.n391 3.4022
R3257 VDD.n1076 VDD.n1075 3.402
R3258 VDD.n1069 VDD.n1068 3.402
R3259 VDD.n1064 VDD.n1063 3.402
R3260 VDD.n1057 VDD.n1056 3.402
R3261 VDD.n1052 VDD.n1051 3.402
R3262 VDD.n1045 VDD.n1044 3.402
R3263 VDD.n1040 VDD.n1039 3.402
R3264 VDD.n1081 VDD.n1080 3.402
R3265 VDD.n1033 VDD.n1032 3.402
R3266 VDD.n1088 VDD.n1087 3.402
R3267 VDD.n1028 VDD.n1027 3.402
R3268 VDD.n1021 VDD.n1020 3.402
R3269 VDD.n2054 VDD.n1990 3.402
R3270 VDD.n2014 VDD.n1983 3.402
R3271 VDD.n2046 VDD.n2045 3.402
R3272 VDD.n2042 VDD.n2041 3.402
R3273 VDD.n2036 VDD.n2035 3.402
R3274 VDD.n2032 VDD.n1981 3.402
R3275 VDD.n2029 VDD.n1949 3.402
R3276 VDD.n2007 VDD.n2006 3.402
R3277 VDD.n2205 VDD.n1946 3.402
R3278 VDD.n2001 VDD.n2000 3.402
R3279 VDD.n2212 VDD.n2211 3.402
R3280 VDD.n1992 VDD.n1988 3.402
R3281 VDD.t71 VDD.n672 3.40192
R3282 VDD.t73 VDD.n730 3.40192
R3283 VDD.t75 VDD.n788 3.40192
R3284 VDD.t598 VDD.n505 3.40192
R3285 VDD.t600 VDD.n448 3.40192
R3286 VDD.t602 VDD.n391 3.40192
R3287 VDD.n1760 VDD.n15 3.39943
R3288 VDD.n2231 VDD.n15 3.38505
R3289 VDD.n604 VDD.n602 3.38397
R3290 VDD.n369 VDD.n368 3.38355
R3291 VDD.n602 VDD.n601 3.30708
R3292 VDD.n371 VDD.n369 3.30592
R3293 VDD.n838 VDD.n837 3.28878
R3294 VDD.n1133 VDD.n21 3.12142
R3295 VDD.n1039 VDD.n1038 3.0005
R3296 VDD.n1046 VDD.n1045 3.0005
R3297 VDD.n1051 VDD.n1050 3.0005
R3298 VDD.n1058 VDD.n1057 3.0005
R3299 VDD.n1063 VDD.n1062 3.0005
R3300 VDD.n1070 VDD.n1069 3.0005
R3301 VDD.n1075 VDD.n1074 3.0005
R3302 VDD.n1082 VDD.n1081 3.0005
R3303 VDD.n987 VDD.n870 3.0005
R3304 VDD.n990 VDD.n872 3.0005
R3305 VDD.n993 VDD.n874 3.0005
R3306 VDD.n996 VDD.n876 3.0005
R3307 VDD.n999 VDD.n878 3.0005
R3308 VDD.n1002 VDD.n880 3.0005
R3309 VDD.n1005 VDD.n882 3.0005
R3310 VDD.n1008 VDD.n884 3.0005
R3311 VDD.n1011 VDD.n886 3.0005
R3312 VDD.n1034 VDD.n1033 3.0005
R3313 VDD.n970 VDD.n969 3.0005
R3314 VDD.n966 VDD.n965 3.0005
R3315 VDD.n958 VDD.n957 3.0005
R3316 VDD.n954 VDD.n953 3.0005
R3317 VDD.n946 VDD.n945 3.0005
R3318 VDD.n942 VDD.n941 3.0005
R3319 VDD.n934 VDD.n933 3.0005
R3320 VDD.n930 VDD.n929 3.0005
R3321 VDD.n922 VDD.n921 3.0005
R3322 VDD.n918 VDD.n917 3.0005
R3323 VDD.n984 VDD.n868 3.0005
R3324 VDD.n1087 VDD.n1086 3.0005
R3325 VDD.n916 VDD.n915 3.0005
R3326 VDD.n924 VDD.n923 3.0005
R3327 VDD.n928 VDD.n927 3.0005
R3328 VDD.n936 VDD.n935 3.0005
R3329 VDD.n940 VDD.n939 3.0005
R3330 VDD.n948 VDD.n947 3.0005
R3331 VDD.n952 VDD.n951 3.0005
R3332 VDD.n960 VDD.n959 3.0005
R3333 VDD.n964 VDD.n963 3.0005
R3334 VDD.n972 VDD.n971 3.0005
R3335 VDD.n976 VDD.n975 3.0005
R3336 VDD.n978 VDD.n977 3.0005
R3337 VDD.n1014 VDD.n888 3.0005
R3338 VDD.n1027 VDD.n1026 3.0005
R3339 VDD.n1128 VDD.n862 3.0005
R3340 VDD.n1125 VDD.n861 3.0005
R3341 VDD.n1122 VDD.n860 3.0005
R3342 VDD.n1119 VDD.n859 3.0005
R3343 VDD.n1116 VDD.n858 3.0005
R3344 VDD.n1113 VDD.n857 3.0005
R3345 VDD.n1110 VDD.n856 3.0005
R3346 VDD.n1107 VDD.n855 3.0005
R3347 VDD.n1104 VDD.n854 3.0005
R3348 VDD.n1101 VDD.n853 3.0005
R3349 VDD.n1098 VDD.n852 3.0005
R3350 VDD.n1095 VDD.n851 3.0005
R3351 VDD.n891 VDD.n889 3.0005
R3352 VDD.n982 VDD.n981 3.0005
R3353 VDD.n1018 VDD.n1017 3.0005
R3354 VDD.n1022 VDD.n1021 3.0005
R3355 VDD.n1539 VDD.n1538 3.0005
R3356 VDD.n1528 VDD.n1524 3.0005
R3357 VDD.n1518 VDD.n1513 3.0005
R3358 VDD.n1551 VDD.n1549 3.0005
R3359 VDD.n1564 VDD.n1563 3.0005
R3360 VDD.n1573 VDD.n1514 3.0005
R3361 VDD.n1570 VDD.n1511 3.0005
R3362 VDD.n1555 VDD.n1554 3.0005
R3363 VDD.n1559 VDD.n1558 3.0005
R3364 VDD.n1534 VDD.n1533 3.0005
R3365 VDD.n1532 VDD.n1531 3.0005
R3366 VDD.n1515 VDD.n1512 3.0005
R3367 VDD.n2112 VDD.n1950 3.0005
R3368 VDD.n2116 VDD.n2115 3.0005
R3369 VDD.n2124 VDD.n2123 3.0005
R3370 VDD.n2128 VDD.n2127 3.0005
R3371 VDD.n2136 VDD.n2135 3.0005
R3372 VDD.n2139 VDD.n1959 3.0005
R3373 VDD.n2143 VDD.n2142 3.0005
R3374 VDD.n2083 VDD.n2082 3.0005
R3375 VDD.n2085 VDD.n2084 3.0005
R3376 VDD.n2088 VDD.n1969 3.0005
R3377 VDD.n2093 VDD.n2092 3.0005
R3378 VDD.n2134 VDD.n2133 3.0005
R3379 VDD.n2130 VDD.n2129 3.0005
R3380 VDD.n2122 VDD.n2121 3.0005
R3381 VDD.n2118 VDD.n2117 3.0005
R3382 VDD.n2194 VDD.n2193 3.0005
R3383 VDD.n2190 VDD.n1947 3.0005
R3384 VDD.n2180 VDD.n2179 3.0005
R3385 VDD.n2204 VDD.n2203 3.0005
R3386 VDD.n2196 VDD.n2195 3.0005
R3387 VDD.n2109 VDD.n2108 3.0005
R3388 VDD.n2104 VDD.n1978 3.0005
R3389 VDD.n2101 VDD.n1975 3.0005
R3390 VDD.n2098 VDD.n1972 3.0005
R3391 VDD.n2095 VDD.n2094 3.0005
R3392 VDD.n2056 VDD.n2055 3.0005
R3393 VDD.n2059 VDD.n1985 3.0005
R3394 VDD.n2062 VDD.n1987 3.0005
R3395 VDD.n2076 VDD.n2075 3.0005
R3396 VDD.n2078 VDD.n2077 3.0005
R3397 VDD.n2000 VDD.n1999 3.0005
R3398 VDD.n2008 VDD.n2007 3.0005
R3399 VDD.n2054 VDD.n2053 3.0005
R3400 VDD.n2050 VDD.n1983 3.0005
R3401 VDD.n2047 VDD.n2046 3.0005
R3402 VDD.n2041 VDD.n2040 3.0005
R3403 VDD.n2037 VDD.n2036 3.0005
R3404 VDD.n2023 VDD.n1981 3.0005
R3405 VDD.n2020 VDD.n1949 3.0005
R3406 VDD.n2206 VDD.n2205 3.0005
R3407 VDD.n2211 VDD.n2210 3.0005
R3408 VDD.n2200 VDD.n1943 3.0005
R3409 VDD.n2187 VDD.n2186 3.0005
R3410 VDD.n2185 VDD.n2184 3.0005
R3411 VDD.n1995 VDD.n1988 3.0005
R3412 VDD.n2066 VDD.n2065 3.0005
R3413 VDD.n2071 VDD.n2070 3.0005
R3414 VDD.n2069 VDD.n2068 3.0005
R3415 VDD.n1960 VDD.n11 3.0005
R3416 VDD.n1963 VDD.n12 3.0005
R3417 VDD.n1966 VDD.n13 3.0005
R3418 VDD.n2145 VDD.n2144 3.0005
R3419 VDD.n2162 VDD.n2161 3.0005
R3420 VDD.n2158 VDD.n1958 3.0005
R3421 VDD.n2155 VDD.n1957 3.0005
R3422 VDD.n2152 VDD.n1956 3.0005
R3423 VDD.n2149 VDD.n1955 3.0005
R3424 VDD.n2170 VDD.n2169 3.0005
R3425 VDD.n2178 VDD.n2177 3.0005
R3426 VDD.n2174 VDD.n1936 3.0005
R3427 VDD.n2225 VDD.n1934 2.95673
R3428 VDD.n1922 VDD.n1920 2.89037
R3429 VDD.n1760 VDD.n22 2.8903
R3430 VDD.n1920 VDD.n25 2.8903
R3431 VDD.n832 VDD.n831 2.8805
R3432 VDD.n835 VDD.n834 2.8805
R3433 VDD.n1921 VDD.n23 2.86169
R3434 VDD.n1143 VDD.n26 2.83277
R3435 VDD.n1190 VDD.n26 2.8249
R3436 VDD.n2224 VDD.n2223 2.52925
R3437 VDD.n831 VDD.t624 2.52803
R3438 VDD.n832 VDD.t623 2.52803
R3439 VDD.n835 VDD.t628 2.52803
R3440 VDD.n834 VDD.t630 2.52803
R3441 VDD.n601 VDD.t643 2.47004
R3442 VDD.n597 VDD.t644 2.47004
R3443 VDD.n598 VDD.t646 2.47004
R3444 VDD.n603 VDD.t648 2.47004
R3445 VDD.n604 VDD.t650 2.47004
R3446 VDD.n368 VDD.t636 2.47004
R3447 VDD.n366 VDD.t637 2.47004
R3448 VDD.n364 VDD.t634 2.47004
R3449 VDD.n370 VDD.t635 2.47004
R3450 VDD.n371 VDD.t641 2.47004
R3451 VDD.n2225 VDD.n2224 2.32665
R3452 VDD.n2238 VDD.n2237 2.26577
R3453 VDD.n1152 VDD.n850 2.26577
R3454 VDD.n2237 VDD.n2236 2.2505
R3455 VDD.n10 VDD.n9 2.2505
R3456 VDD.n1774 VDD.n7 2.2505
R3457 VDD.n1775 VDD.n6 2.2505
R3458 VDD.n1776 VDD.n5 2.2505
R3459 VDD.n1778 VDD.n1777 2.2505
R3460 VDD.n1779 VDD.n1773 2.2505
R3461 VDD.n1772 VDD.n1462 2.2505
R3462 VDD.n1771 VDD.n1461 2.2505
R3463 VDD.n1770 VDD.n1769 2.2505
R3464 VDD.n1768 VDD.n1458 2.2505
R3465 VDD.n1767 VDD.n1457 2.2505
R3466 VDD.n1766 VDD.n1456 2.2505
R3467 VDD.n1765 VDD.n1764 2.2505
R3468 VDD.n1763 VDD.n1452 2.2505
R3469 VDD.n1762 VDD.n1451 2.2505
R3470 VDD.n1759 VDD.n1450 2.2505
R3471 VDD.n1758 VDD.n1757 2.2505
R3472 VDD.n1756 VDD.n1447 2.2505
R3473 VDD.n1755 VDD.n1446 2.2505
R3474 VDD.n1754 VDD.n1445 2.2505
R3475 VDD.n1753 VDD.n1752 2.2505
R3476 VDD.n1751 VDD.n1442 2.2505
R3477 VDD.n1750 VDD.n1441 2.2505
R3478 VDD.n1749 VDD.n1440 2.2505
R3479 VDD.n1748 VDD.n1747 2.2505
R3480 VDD.n1746 VDD.n1463 2.2505
R3481 VDD.n1738 VDD.n1464 2.2505
R3482 VDD.n1740 VDD.n1739 2.2505
R3483 VDD.n1737 VDD.n1468 2.2505
R3484 VDD.n1736 VDD.n1735 2.2505
R3485 VDD.n1470 VDD.n1469 2.2505
R3486 VDD.n1729 VDD.n1728 2.2505
R3487 VDD.n1727 VDD.n1474 2.2505
R3488 VDD.n1726 VDD.n1725 2.2505
R3489 VDD.n1723 VDD.n1722 2.2505
R3490 VDD.n1721 VDD.n1434 2.2505
R3491 VDD.n1720 VDD.n1433 2.2505
R3492 VDD.n1719 VDD.n1432 2.2505
R3493 VDD.n1718 VDD.n1717 2.2505
R3494 VDD.n1716 VDD.n1429 2.2505
R3495 VDD.n1715 VDD.n1428 2.2505
R3496 VDD.n1714 VDD.n1427 2.2505
R3497 VDD.n1713 VDD.n1712 2.2505
R3498 VDD.n1711 VDD.n1423 2.2505
R3499 VDD.n1710 VDD.n1422 2.2505
R3500 VDD.n1709 VDD.n1421 2.2505
R3501 VDD.n1708 VDD.n1707 2.2505
R3502 VDD.n1706 VDD.n1418 2.2505
R3503 VDD.n1705 VDD.n1417 2.2505
R3504 VDD.n1704 VDD.n1416 2.2505
R3505 VDD.n1703 VDD.n1702 2.2505
R3506 VDD.n1701 VDD.n1413 2.2505
R3507 VDD.n1700 VDD.n1412 2.2505
R3508 VDD.n1699 VDD.n1411 2.2505
R3509 VDD.n1698 VDD.n1697 2.2505
R3510 VDD.n1696 VDD.n1475 2.2505
R3511 VDD.n1688 VDD.n1476 2.2505
R3512 VDD.n1690 VDD.n1689 2.2505
R3513 VDD.n1687 VDD.n1480 2.2505
R3514 VDD.n1686 VDD.n1685 2.2505
R3515 VDD.n1482 VDD.n1481 2.2505
R3516 VDD.n1679 VDD.n1678 2.2505
R3517 VDD.n1677 VDD.n1486 2.2505
R3518 VDD.n1676 VDD.n1675 2.2505
R3519 VDD.n1673 VDD.n1672 2.2505
R3520 VDD.n1671 VDD.n1404 2.2505
R3521 VDD.n1670 VDD.n1403 2.2505
R3522 VDD.n1669 VDD.n1402 2.2505
R3523 VDD.n1668 VDD.n1667 2.2505
R3524 VDD.n1666 VDD.n1399 2.2505
R3525 VDD.n1665 VDD.n1398 2.2505
R3526 VDD.n1664 VDD.n1397 2.2505
R3527 VDD.n1663 VDD.n1662 2.2505
R3528 VDD.n1659 VDD.n1393 2.2505
R3529 VDD.n1658 VDD.n1392 2.2505
R3530 VDD.n1657 VDD.n1391 2.2505
R3531 VDD.n1656 VDD.n1655 2.2505
R3532 VDD.n1654 VDD.n1388 2.2505
R3533 VDD.n1653 VDD.n1387 2.2505
R3534 VDD.n1652 VDD.n1386 2.2505
R3535 VDD.n1651 VDD.n1650 2.2505
R3536 VDD.n1649 VDD.n1383 2.2505
R3537 VDD.n1648 VDD.n1382 2.2505
R3538 VDD.n1647 VDD.n1381 2.2505
R3539 VDD.n1646 VDD.n1645 2.2505
R3540 VDD.n1644 VDD.n1487 2.2505
R3541 VDD.n1636 VDD.n1488 2.2505
R3542 VDD.n1638 VDD.n1637 2.2505
R3543 VDD.n1635 VDD.n1492 2.2505
R3544 VDD.n1634 VDD.n1633 2.2505
R3545 VDD.n1494 VDD.n1493 2.2505
R3546 VDD.n1627 VDD.n1626 2.2505
R3547 VDD.n1510 VDD.n1498 2.2505
R3548 VDD.n1510 VDD.n1361 2.2505
R3549 VDD.n1624 VDD.n1623 2.2505
R3550 VDD.n1622 VDD.n1358 2.2505
R3551 VDD.n1621 VDD.n1357 2.2505
R3552 VDD.n1620 VDD.n1356 2.2505
R3553 VDD.n1619 VDD.n1618 2.2505
R3554 VDD.n1617 VDD.n1353 2.2505
R3555 VDD.n1616 VDD.n1352 2.2505
R3556 VDD.n1615 VDD.n1351 2.2505
R3557 VDD.n1614 VDD.n1613 2.2505
R3558 VDD.n1612 VDD.n1581 2.2505
R3559 VDD.n1604 VDD.n1582 2.2505
R3560 VDD.n1606 VDD.n1605 2.2505
R3561 VDD.n1603 VDD.n1586 2.2505
R3562 VDD.n1602 VDD.n1601 2.2505
R3563 VDD.n1588 VDD.n1587 2.2505
R3564 VDD.n1595 VDD.n1594 2.2505
R3565 VDD.n1593 VDD.n1592 2.2505
R3566 VDD.n31 VDD.n29 2.2505
R3567 VDD.n1918 VDD.n1917 2.2505
R3568 VDD.n30 VDD.n28 2.2505
R3569 VDD.n1331 VDD.n1330 2.2505
R3570 VDD.n1329 VDD.n47 2.2505
R3571 VDD.n1328 VDD.n46 2.2505
R3572 VDD.n1327 VDD.n45 2.2505
R3573 VDD.n1326 VDD.n1325 2.2505
R3574 VDD.n1324 VDD.n42 2.2505
R3575 VDD.n1323 VDD.n41 2.2505
R3576 VDD.n1322 VDD.n40 2.2505
R3577 VDD.n1321 VDD.n1320 2.2505
R3578 VDD.n1319 VDD.n48 2.2505
R3579 VDD.n1311 VDD.n49 2.2505
R3580 VDD.n1313 VDD.n1312 2.2505
R3581 VDD.n1310 VDD.n53 2.2505
R3582 VDD.n1309 VDD.n1308 2.2505
R3583 VDD.n55 VDD.n54 2.2505
R3584 VDD.n1302 VDD.n1301 2.2505
R3585 VDD.n1300 VDD.n59 2.2505
R3586 VDD.n1299 VDD.n1298 2.2505
R3587 VDD.n61 VDD.n60 2.2505
R3588 VDD.n1291 VDD.n1290 2.2505
R3589 VDD.n1289 VDD.n65 2.2505
R3590 VDD.n1288 VDD.n1287 2.2505
R3591 VDD.n67 VDD.n66 2.2505
R3592 VDD.n1281 VDD.n1280 2.2505
R3593 VDD.n1279 VDD.n71 2.2505
R3594 VDD.n1278 VDD.n1277 2.2505
R3595 VDD.n73 VDD.n72 2.2505
R3596 VDD.n1271 VDD.n1270 2.2505
R3597 VDD.n1269 VDD.n77 2.2505
R3598 VDD.n1268 VDD.n1267 2.2505
R3599 VDD.n79 VDD.n78 2.2505
R3600 VDD.n1260 VDD.n1259 2.2505
R3601 VDD.n1258 VDD.n83 2.2505
R3602 VDD.n1257 VDD.n1256 2.2505
R3603 VDD.n85 VDD.n84 2.2505
R3604 VDD.n1250 VDD.n1249 2.2505
R3605 VDD.n1248 VDD.n89 2.2505
R3606 VDD.n1247 VDD.n1246 2.2505
R3607 VDD.n91 VDD.n90 2.2505
R3608 VDD.n1224 VDD.n1223 2.2505
R3609 VDD.n1222 VDD.n107 2.2505
R3610 VDD.n1221 VDD.n105 2.2505
R3611 VDD.n1220 VDD.n104 2.2505
R3612 VDD.n1219 VDD.n103 2.2505
R3613 VDD.n1218 VDD.n1217 2.2505
R3614 VDD.n1216 VDD.n100 2.2505
R3615 VDD.n1215 VDD.n99 2.2505
R3616 VDD.n1214 VDD.n98 2.2505
R3617 VDD.n1213 VDD.n1212 2.2505
R3618 VDD.n1211 VDD.n108 2.2505
R3619 VDD.n1203 VDD.n109 2.2505
R3620 VDD.n1205 VDD.n1204 2.2505
R3621 VDD.n1202 VDD.n113 2.2505
R3622 VDD.n1201 VDD.n1200 2.2505
R3623 VDD.n115 VDD.n114 2.2505
R3624 VDD.n1194 VDD.n1193 2.2505
R3625 VDD.n1192 VDD.n119 2.2505
R3626 VDD.n1189 VDD.n1188 2.2505
R3627 VDD.n121 VDD.n120 2.2505
R3628 VDD.n1181 VDD.n1180 2.2505
R3629 VDD.n1179 VDD.n125 2.2505
R3630 VDD.n1178 VDD.n1177 2.2505
R3631 VDD.n127 VDD.n126 2.2505
R3632 VDD.n1171 VDD.n1170 2.2505
R3633 VDD.n1169 VDD.n131 2.2505
R3634 VDD.n1168 VDD.n1167 2.2505
R3635 VDD.n133 VDD.n132 2.2505
R3636 VDD.n1161 VDD.n1160 2.2505
R3637 VDD.n1159 VDD.n846 2.2505
R3638 VDD.n1158 VDD.n1157 2.2505
R3639 VDD.n848 VDD.n847 2.2505
R3640 VDD.n1150 VDD.n1149 2.2505
R3641 VDD.n1148 VDD.n850 2.2505
R3642 VDD.n9 VDD.n8 2.2505
R3643 VDD.n2240 VDD.n7 2.2505
R3644 VDD.n2241 VDD.n6 2.2505
R3645 VDD.n2242 VDD.n5 2.2505
R3646 VDD.n1778 VDD.n4 2.2505
R3647 VDD.n1781 VDD.n1779 2.2505
R3648 VDD.n1782 VDD.n1462 2.2505
R3649 VDD.n1783 VDD.n1461 2.2505
R3650 VDD.n1769 VDD.n1459 2.2505
R3651 VDD.n1787 VDD.n1458 2.2505
R3652 VDD.n1788 VDD.n1457 2.2505
R3653 VDD.n1789 VDD.n1456 2.2505
R3654 VDD.n1764 VDD.n1453 2.2505
R3655 VDD.n1793 VDD.n1452 2.2505
R3656 VDD.n1794 VDD.n1451 2.2505
R3657 VDD.n1795 VDD.n1450 2.2505
R3658 VDD.n1757 VDD.n1448 2.2505
R3659 VDD.n1799 VDD.n1447 2.2505
R3660 VDD.n1800 VDD.n1446 2.2505
R3661 VDD.n1801 VDD.n1445 2.2505
R3662 VDD.n1752 VDD.n1443 2.2505
R3663 VDD.n1805 VDD.n1442 2.2505
R3664 VDD.n1806 VDD.n1441 2.2505
R3665 VDD.n1807 VDD.n1440 2.2505
R3666 VDD.n1747 VDD.n1439 2.2505
R3667 VDD.n1746 VDD.n1745 2.2505
R3668 VDD.n1465 VDD.n1464 2.2505
R3669 VDD.n1741 VDD.n1740 2.2505
R3670 VDD.n1468 VDD.n1467 2.2505
R3671 VDD.n1735 VDD.n1734 2.2505
R3672 VDD.n1471 VDD.n1470 2.2505
R3673 VDD.n1730 VDD.n1729 2.2505
R3674 VDD.n1474 VDD.n1473 2.2505
R3675 VDD.n1725 VDD.n1724 2.2505
R3676 VDD.n1723 VDD.n1435 2.2505
R3677 VDD.n1815 VDD.n1434 2.2505
R3678 VDD.n1816 VDD.n1433 2.2505
R3679 VDD.n1817 VDD.n1432 2.2505
R3680 VDD.n1717 VDD.n1430 2.2505
R3681 VDD.n1821 VDD.n1429 2.2505
R3682 VDD.n1822 VDD.n1428 2.2505
R3683 VDD.n1823 VDD.n1427 2.2505
R3684 VDD.n1712 VDD.n1424 2.2505
R3685 VDD.n1827 VDD.n1423 2.2505
R3686 VDD.n1828 VDD.n1422 2.2505
R3687 VDD.n1829 VDD.n1421 2.2505
R3688 VDD.n1707 VDD.n1419 2.2505
R3689 VDD.n1833 VDD.n1418 2.2505
R3690 VDD.n1834 VDD.n1417 2.2505
R3691 VDD.n1835 VDD.n1416 2.2505
R3692 VDD.n1702 VDD.n1414 2.2505
R3693 VDD.n1839 VDD.n1413 2.2505
R3694 VDD.n1840 VDD.n1412 2.2505
R3695 VDD.n1841 VDD.n1411 2.2505
R3696 VDD.n1697 VDD.n1410 2.2505
R3697 VDD.n1696 VDD.n1695 2.2505
R3698 VDD.n1477 VDD.n1476 2.2505
R3699 VDD.n1691 VDD.n1690 2.2505
R3700 VDD.n1480 VDD.n1479 2.2505
R3701 VDD.n1685 VDD.n1684 2.2505
R3702 VDD.n1483 VDD.n1482 2.2505
R3703 VDD.n1680 VDD.n1679 2.2505
R3704 VDD.n1486 VDD.n1485 2.2505
R3705 VDD.n1675 VDD.n1674 2.2505
R3706 VDD.n1673 VDD.n1405 2.2505
R3707 VDD.n1849 VDD.n1404 2.2505
R3708 VDD.n1850 VDD.n1403 2.2505
R3709 VDD.n1851 VDD.n1402 2.2505
R3710 VDD.n1667 VDD.n1400 2.2505
R3711 VDD.n1855 VDD.n1399 2.2505
R3712 VDD.n1856 VDD.n1398 2.2505
R3713 VDD.n1857 VDD.n1397 2.2505
R3714 VDD.n1662 VDD.n1394 2.2505
R3715 VDD.n1861 VDD.n1393 2.2505
R3716 VDD.n1862 VDD.n1392 2.2505
R3717 VDD.n1863 VDD.n1391 2.2505
R3718 VDD.n1655 VDD.n1389 2.2505
R3719 VDD.n1867 VDD.n1388 2.2505
R3720 VDD.n1868 VDD.n1387 2.2505
R3721 VDD.n1869 VDD.n1386 2.2505
R3722 VDD.n1650 VDD.n1384 2.2505
R3723 VDD.n1873 VDD.n1383 2.2505
R3724 VDD.n1874 VDD.n1382 2.2505
R3725 VDD.n1875 VDD.n1381 2.2505
R3726 VDD.n1645 VDD.n1380 2.2505
R3727 VDD.n1644 VDD.n1643 2.2505
R3728 VDD.n1489 VDD.n1488 2.2505
R3729 VDD.n1639 VDD.n1638 2.2505
R3730 VDD.n1492 VDD.n1491 2.2505
R3731 VDD.n1633 VDD.n1632 2.2505
R3732 VDD.n1495 VDD.n1494 2.2505
R3733 VDD.n1628 VDD.n1627 2.2505
R3734 VDD.n1498 VDD.n1497 2.2505
R3735 VDD.n1508 VDD.n1507 2.2505
R3736 VDD.n1506 VDD.n1375 2.2505
R3737 VDD.n1883 VDD.n1374 2.2505
R3738 VDD.n1884 VDD.n1373 2.2505
R3739 VDD.n1885 VDD.n1372 2.2505
R3740 VDD.n1503 VDD.n1370 2.2505
R3741 VDD.n1889 VDD.n1369 2.2505
R3742 VDD.n1890 VDD.n1368 2.2505
R3743 VDD.n1891 VDD.n1367 2.2505
R3744 VDD.n1500 VDD.n1364 2.2505
R3745 VDD.n1895 VDD.n1363 2.2505
R3746 VDD.n1896 VDD.n1362 2.2505
R3747 VDD.n1897 VDD.n1361 2.2505
R3748 VDD.n1623 VDD.n1359 2.2505
R3749 VDD.n1901 VDD.n1358 2.2505
R3750 VDD.n1902 VDD.n1357 2.2505
R3751 VDD.n1903 VDD.n1356 2.2505
R3752 VDD.n1618 VDD.n1354 2.2505
R3753 VDD.n1907 VDD.n1353 2.2505
R3754 VDD.n1908 VDD.n1352 2.2505
R3755 VDD.n1909 VDD.n1351 2.2505
R3756 VDD.n1613 VDD.n1350 2.2505
R3757 VDD.n1612 VDD.n1611 2.2505
R3758 VDD.n1583 VDD.n1582 2.2505
R3759 VDD.n1607 VDD.n1606 2.2505
R3760 VDD.n1586 VDD.n1585 2.2505
R3761 VDD.n1601 VDD.n1600 2.2505
R3762 VDD.n1589 VDD.n1588 2.2505
R3763 VDD.n1596 VDD.n1595 2.2505
R3764 VDD.n1592 VDD.n1591 2.2505
R3765 VDD.n33 VDD.n31 2.2505
R3766 VDD.n1917 VDD.n1916 2.2505
R3767 VDD.n32 VDD.n30 2.2505
R3768 VDD.n1332 VDD.n1331 2.2505
R3769 VDD.n1335 VDD.n47 2.2505
R3770 VDD.n1336 VDD.n46 2.2505
R3771 VDD.n1337 VDD.n45 2.2505
R3772 VDD.n1325 VDD.n43 2.2505
R3773 VDD.n1341 VDD.n42 2.2505
R3774 VDD.n1342 VDD.n41 2.2505
R3775 VDD.n1343 VDD.n40 2.2505
R3776 VDD.n1320 VDD.n39 2.2505
R3777 VDD.n1319 VDD.n1318 2.2505
R3778 VDD.n50 VDD.n49 2.2505
R3779 VDD.n1314 VDD.n1313 2.2505
R3780 VDD.n53 VDD.n52 2.2505
R3781 VDD.n1308 VDD.n1307 2.2505
R3782 VDD.n56 VDD.n55 2.2505
R3783 VDD.n1303 VDD.n1302 2.2505
R3784 VDD.n59 VDD.n58 2.2505
R3785 VDD.n1298 VDD.n1297 2.2505
R3786 VDD.n62 VDD.n61 2.2505
R3787 VDD.n1292 VDD.n1291 2.2505
R3788 VDD.n65 VDD.n64 2.2505
R3789 VDD.n1287 VDD.n1286 2.2505
R3790 VDD.n68 VDD.n67 2.2505
R3791 VDD.n1282 VDD.n1281 2.2505
R3792 VDD.n71 VDD.n70 2.2505
R3793 VDD.n1277 VDD.n1276 2.2505
R3794 VDD.n74 VDD.n73 2.2505
R3795 VDD.n1272 VDD.n1271 2.2505
R3796 VDD.n77 VDD.n76 2.2505
R3797 VDD.n1267 VDD.n1266 2.2505
R3798 VDD.n80 VDD.n79 2.2505
R3799 VDD.n1261 VDD.n1260 2.2505
R3800 VDD.n83 VDD.n82 2.2505
R3801 VDD.n1256 VDD.n1255 2.2505
R3802 VDD.n86 VDD.n85 2.2505
R3803 VDD.n1251 VDD.n1250 2.2505
R3804 VDD.n89 VDD.n88 2.2505
R3805 VDD.n1246 VDD.n1245 2.2505
R3806 VDD.n92 VDD.n91 2.2505
R3807 VDD.n1225 VDD.n1224 2.2505
R3808 VDD.n107 VDD.n106 2.2505
R3809 VDD.n1229 VDD.n105 2.2505
R3810 VDD.n1230 VDD.n104 2.2505
R3811 VDD.n1231 VDD.n103 2.2505
R3812 VDD.n1217 VDD.n101 2.2505
R3813 VDD.n1235 VDD.n100 2.2505
R3814 VDD.n1236 VDD.n99 2.2505
R3815 VDD.n1237 VDD.n98 2.2505
R3816 VDD.n1212 VDD.n97 2.2505
R3817 VDD.n1211 VDD.n1210 2.2505
R3818 VDD.n110 VDD.n109 2.2505
R3819 VDD.n1206 VDD.n1205 2.2505
R3820 VDD.n113 VDD.n112 2.2505
R3821 VDD.n1200 VDD.n1199 2.2505
R3822 VDD.n116 VDD.n115 2.2505
R3823 VDD.n1195 VDD.n1194 2.2505
R3824 VDD.n119 VDD.n118 2.2505
R3825 VDD.n1188 VDD.n1187 2.2505
R3826 VDD.n122 VDD.n121 2.2505
R3827 VDD.n1182 VDD.n1181 2.2505
R3828 VDD.n125 VDD.n124 2.2505
R3829 VDD.n1177 VDD.n1176 2.2505
R3830 VDD.n128 VDD.n127 2.2505
R3831 VDD.n1172 VDD.n1171 2.2505
R3832 VDD.n131 VDD.n130 2.2505
R3833 VDD.n1167 VDD.n1166 2.2505
R3834 VDD.n134 VDD.n133 2.2505
R3835 VDD.n1162 VDD.n1161 2.2505
R3836 VDD.n846 VDD.n845 2.2505
R3837 VDD.n1157 VDD.n1156 2.2505
R3838 VDD.n849 VDD.n848 2.2505
R3839 VDD.n1151 VDD.n1150 2.2505
R3840 VDD.n2240 VDD.n2239 2.2505
R3841 VDD.n2241 VDD.n3 2.2505
R3842 VDD.n2243 VDD.n2242 2.2505
R3843 VDD.n4 VDD.n2 2.2505
R3844 VDD.n1781 VDD.n1780 2.2505
R3845 VDD.n1782 VDD.n1460 2.2505
R3846 VDD.n1784 VDD.n1783 2.2505
R3847 VDD.n1785 VDD.n1459 2.2505
R3848 VDD.n1787 VDD.n1786 2.2505
R3849 VDD.n1788 VDD.n1455 2.2505
R3850 VDD.n1790 VDD.n1789 2.2505
R3851 VDD.n1791 VDD.n1453 2.2505
R3852 VDD.n1793 VDD.n1792 2.2505
R3853 VDD.n1794 VDD.n1449 2.2505
R3854 VDD.n1796 VDD.n1795 2.2505
R3855 VDD.n1797 VDD.n1448 2.2505
R3856 VDD.n1799 VDD.n1798 2.2505
R3857 VDD.n1800 VDD.n1444 2.2505
R3858 VDD.n1802 VDD.n1801 2.2505
R3859 VDD.n1803 VDD.n1443 2.2505
R3860 VDD.n1805 VDD.n1804 2.2505
R3861 VDD.n1806 VDD.n1438 2.2505
R3862 VDD.n1808 VDD.n1807 2.2505
R3863 VDD.n1439 VDD.n1437 2.2505
R3864 VDD.n1745 VDD.n1744 2.2505
R3865 VDD.n1743 VDD.n1465 2.2505
R3866 VDD.n1742 VDD.n1741 2.2505
R3867 VDD.n1467 VDD.n1466 2.2505
R3868 VDD.n1734 VDD.n1733 2.2505
R3869 VDD.n1732 VDD.n1471 2.2505
R3870 VDD.n1731 VDD.n1730 2.2505
R3871 VDD.n1473 VDD.n1472 2.2505
R3872 VDD.n1724 VDD.n1436 2.2505
R3873 VDD.n1813 VDD.n1435 2.2505
R3874 VDD.n1815 VDD.n1814 2.2505
R3875 VDD.n1816 VDD.n1431 2.2505
R3876 VDD.n1818 VDD.n1817 2.2505
R3877 VDD.n1819 VDD.n1430 2.2505
R3878 VDD.n1821 VDD.n1820 2.2505
R3879 VDD.n1822 VDD.n1426 2.2505
R3880 VDD.n1824 VDD.n1823 2.2505
R3881 VDD.n1825 VDD.n1424 2.2505
R3882 VDD.n1827 VDD.n1826 2.2505
R3883 VDD.n1828 VDD.n1420 2.2505
R3884 VDD.n1830 VDD.n1829 2.2505
R3885 VDD.n1831 VDD.n1419 2.2505
R3886 VDD.n1833 VDD.n1832 2.2505
R3887 VDD.n1834 VDD.n1415 2.2505
R3888 VDD.n1836 VDD.n1835 2.2505
R3889 VDD.n1837 VDD.n1414 2.2505
R3890 VDD.n1839 VDD.n1838 2.2505
R3891 VDD.n1840 VDD.n1409 2.2505
R3892 VDD.n1842 VDD.n1841 2.2505
R3893 VDD.n1410 VDD.n1408 2.2505
R3894 VDD.n1695 VDD.n1694 2.2505
R3895 VDD.n1693 VDD.n1477 2.2505
R3896 VDD.n1692 VDD.n1691 2.2505
R3897 VDD.n1479 VDD.n1478 2.2505
R3898 VDD.n1684 VDD.n1683 2.2505
R3899 VDD.n1682 VDD.n1483 2.2505
R3900 VDD.n1681 VDD.n1680 2.2505
R3901 VDD.n1485 VDD.n1484 2.2505
R3902 VDD.n1674 VDD.n1406 2.2505
R3903 VDD.n1847 VDD.n1405 2.2505
R3904 VDD.n1849 VDD.n1848 2.2505
R3905 VDD.n1850 VDD.n1401 2.2505
R3906 VDD.n1852 VDD.n1851 2.2505
R3907 VDD.n1853 VDD.n1400 2.2505
R3908 VDD.n1855 VDD.n1854 2.2505
R3909 VDD.n1856 VDD.n1396 2.2505
R3910 VDD.n1858 VDD.n1857 2.2505
R3911 VDD.n1859 VDD.n1394 2.2505
R3912 VDD.n1861 VDD.n1860 2.2505
R3913 VDD.n1862 VDD.n1390 2.2505
R3914 VDD.n1864 VDD.n1863 2.2505
R3915 VDD.n1865 VDD.n1389 2.2505
R3916 VDD.n1867 VDD.n1866 2.2505
R3917 VDD.n1868 VDD.n1385 2.2505
R3918 VDD.n1870 VDD.n1869 2.2505
R3919 VDD.n1871 VDD.n1384 2.2505
R3920 VDD.n1873 VDD.n1872 2.2505
R3921 VDD.n1874 VDD.n1379 2.2505
R3922 VDD.n1876 VDD.n1875 2.2505
R3923 VDD.n1380 VDD.n1378 2.2505
R3924 VDD.n1643 VDD.n1642 2.2505
R3925 VDD.n1641 VDD.n1489 2.2505
R3926 VDD.n1640 VDD.n1639 2.2505
R3927 VDD.n1491 VDD.n1490 2.2505
R3928 VDD.n1632 VDD.n1631 2.2505
R3929 VDD.n1630 VDD.n1495 2.2505
R3930 VDD.n1629 VDD.n1628 2.2505
R3931 VDD.n1497 VDD.n1496 2.2505
R3932 VDD.n1507 VDD.n1376 2.2505
R3933 VDD.n1881 VDD.n1375 2.2505
R3934 VDD.n1883 VDD.n1882 2.2505
R3935 VDD.n1884 VDD.n1371 2.2505
R3936 VDD.n1886 VDD.n1885 2.2505
R3937 VDD.n1887 VDD.n1370 2.2505
R3938 VDD.n1889 VDD.n1888 2.2505
R3939 VDD.n1890 VDD.n1366 2.2505
R3940 VDD.n1892 VDD.n1891 2.2505
R3941 VDD.n1893 VDD.n1364 2.2505
R3942 VDD.n1895 VDD.n1894 2.2505
R3943 VDD.n1896 VDD.n1360 2.2505
R3944 VDD.n1898 VDD.n1897 2.2505
R3945 VDD.n1899 VDD.n1359 2.2505
R3946 VDD.n1901 VDD.n1900 2.2505
R3947 VDD.n1902 VDD.n1355 2.2505
R3948 VDD.n1904 VDD.n1903 2.2505
R3949 VDD.n1905 VDD.n1354 2.2505
R3950 VDD.n1907 VDD.n1906 2.2505
R3951 VDD.n1908 VDD.n1349 2.2505
R3952 VDD.n1910 VDD.n1909 2.2505
R3953 VDD.n1350 VDD.n1348 2.2505
R3954 VDD.n1611 VDD.n1610 2.2505
R3955 VDD.n1609 VDD.n1583 2.2505
R3956 VDD.n1608 VDD.n1607 2.2505
R3957 VDD.n1585 VDD.n1584 2.2505
R3958 VDD.n1600 VDD.n1599 2.2505
R3959 VDD.n1598 VDD.n1589 2.2505
R3960 VDD.n1597 VDD.n1596 2.2505
R3961 VDD.n1591 VDD.n1590 2.2505
R3962 VDD.n35 VDD.n33 2.2505
R3963 VDD.n1916 VDD.n1915 2.2505
R3964 VDD.n34 VDD.n32 2.2505
R3965 VDD.n1333 VDD.n1332 2.2505
R3966 VDD.n1335 VDD.n1334 2.2505
R3967 VDD.n1336 VDD.n44 2.2505
R3968 VDD.n1338 VDD.n1337 2.2505
R3969 VDD.n1339 VDD.n43 2.2505
R3970 VDD.n1341 VDD.n1340 2.2505
R3971 VDD.n1342 VDD.n38 2.2505
R3972 VDD.n1344 VDD.n1343 2.2505
R3973 VDD.n39 VDD.n37 2.2505
R3974 VDD.n1318 VDD.n1317 2.2505
R3975 VDD.n1316 VDD.n50 2.2505
R3976 VDD.n1315 VDD.n1314 2.2505
R3977 VDD.n52 VDD.n51 2.2505
R3978 VDD.n1307 VDD.n1306 2.2505
R3979 VDD.n1305 VDD.n56 2.2505
R3980 VDD.n1304 VDD.n1303 2.2505
R3981 VDD.n58 VDD.n57 2.2505
R3982 VDD.n1297 VDD.n1296 2.2505
R3983 VDD.n1294 VDD.n62 2.2505
R3984 VDD.n1293 VDD.n1292 2.2505
R3985 VDD.n64 VDD.n63 2.2505
R3986 VDD.n1286 VDD.n1285 2.2505
R3987 VDD.n1284 VDD.n68 2.2505
R3988 VDD.n1283 VDD.n1282 2.2505
R3989 VDD.n70 VDD.n69 2.2505
R3990 VDD.n1276 VDD.n1275 2.2505
R3991 VDD.n1274 VDD.n74 2.2505
R3992 VDD.n1273 VDD.n1272 2.2505
R3993 VDD.n1264 VDD.n76 2.2505
R3994 VDD.n1266 VDD.n1265 2.2505
R3995 VDD.n1263 VDD.n80 2.2505
R3996 VDD.n1262 VDD.n1261 2.2505
R3997 VDD.n82 VDD.n81 2.2505
R3998 VDD.n1255 VDD.n1254 2.2505
R3999 VDD.n1253 VDD.n86 2.2505
R4000 VDD.n1252 VDD.n1251 2.2505
R4001 VDD.n88 VDD.n87 2.2505
R4002 VDD.n1245 VDD.n1244 2.2505
R4003 VDD.n93 VDD.n92 2.2505
R4004 VDD.n1226 VDD.n1225 2.2505
R4005 VDD.n1227 VDD.n106 2.2505
R4006 VDD.n1229 VDD.n1228 2.2505
R4007 VDD.n1230 VDD.n102 2.2505
R4008 VDD.n1232 VDD.n1231 2.2505
R4009 VDD.n1233 VDD.n101 2.2505
R4010 VDD.n1235 VDD.n1234 2.2505
R4011 VDD.n1236 VDD.n96 2.2505
R4012 VDD.n1238 VDD.n1237 2.2505
R4013 VDD.n97 VDD.n95 2.2505
R4014 VDD.n1210 VDD.n1209 2.2505
R4015 VDD.n1208 VDD.n110 2.2505
R4016 VDD.n1207 VDD.n1206 2.2505
R4017 VDD.n112 VDD.n111 2.2505
R4018 VDD.n1199 VDD.n1198 2.2505
R4019 VDD.n1197 VDD.n116 2.2505
R4020 VDD.n1196 VDD.n1195 2.2505
R4021 VDD.n118 VDD.n117 2.2505
R4022 VDD.n1187 VDD.n1186 2.2505
R4023 VDD.n1184 VDD.n122 2.2505
R4024 VDD.n1183 VDD.n1182 2.2505
R4025 VDD.n124 VDD.n123 2.2505
R4026 VDD.n1176 VDD.n1175 2.2505
R4027 VDD.n1174 VDD.n128 2.2505
R4028 VDD.n1173 VDD.n1172 2.2505
R4029 VDD.n130 VDD.n129 2.2505
R4030 VDD.n1166 VDD.n1165 2.2505
R4031 VDD.n1164 VDD.n134 2.2505
R4032 VDD.n1163 VDD.n1162 2.2505
R4033 VDD.n1154 VDD.n845 2.2505
R4034 VDD.n1156 VDD.n1155 2.2505
R4035 VDD.n1153 VDD.n849 2.2505
R4036 VDD.n362 VDD.n361 2.2005
R4037 VDD.n360 VDD.n135 2.2005
R4038 VDD.n359 VDD.n358 2.2005
R4039 VDD.n357 VDD.n139 2.2005
R4040 VDD.n356 VDD.n355 2.2005
R4041 VDD.n354 VDD.n140 2.2005
R4042 VDD.n353 VDD.n352 2.2005
R4043 VDD.n351 VDD.n144 2.2005
R4044 VDD.n350 VDD.n349 2.2005
R4045 VDD.n348 VDD.n145 2.2005
R4046 VDD.n347 VDD.n346 2.2005
R4047 VDD.n844 VDD.n843 2.2005
R4048 VDD.n1185 VDD.n94 2.2005
R4049 VDD.n1240 VDD.n1239 2.2005
R4050 VDD.n1243 VDD.n1242 2.2005
R4051 VDD.n1241 VDD.n75 2.2005
R4052 VDD.n1295 VDD.n36 2.2005
R4053 VDD.n1346 VDD.n1345 2.2005
R4054 VDD.n1914 VDD.n1913 2.2005
R4055 VDD.n1912 VDD.n1911 2.2005
R4056 VDD.n1365 VDD.n1347 2.2005
R4057 VDD.n1880 VDD.n1879 2.2005
R4058 VDD.n1878 VDD.n1877 2.2005
R4059 VDD.n1395 VDD.n1377 2.2005
R4060 VDD.n1846 VDD.n1845 2.2005
R4061 VDD.n1844 VDD.n1843 2.2005
R4062 VDD.n1425 VDD.n1407 2.2005
R4063 VDD.n1812 VDD.n1811 2.2005
R4064 VDD.n1810 VDD.n1809 2.2005
R4065 VDD.n1454 VDD.n1 2.2005
R4066 VDD.n2245 VDD.n2244 2.2005
R4067 VDD.n1531 VDD.t41 2.04614
R4068 VDD.n1534 VDD.t43 2.04614
R4069 VDD.n1559 VDD.t3 2.04614
R4070 VDD.n1554 VDD.t5 2.04614
R4071 VDD.n1515 VDD.t40 2.04319
R4072 VDD.n1526 VDD.t45 2.04319
R4073 VDD.n1557 VDD.t2 2.04319
R4074 VDD.n1570 VDD.t7 2.04319
R4075 VDD.n1660 VDD.n23 1.93688
R4076 VDD.n1516 VDD.n1515 1.67523
R4077 VDD.n1519 VDD.n1518 1.67523
R4078 VDD.n1557 VDD.n1556 1.67523
R4079 VDD.n1566 VDD.n1565 1.67523
R4080 VDD.n1531 VDD.n1530 1.67502
R4081 VDD.n1535 VDD.n1534 1.67502
R4082 VDD.n1560 VDD.n1559 1.67502
R4083 VDD.n1554 VDD.n1553 1.67502
R4084 VDD.n1528 VDD.n1527 1.67502
R4085 VDD.n1538 VDD.n1537 1.67502
R4086 VDD.n1541 VDD.n1540 1.67502
R4087 VDD.n1526 VDD.n1525 1.67502
R4088 VDD.n1563 VDD.n1562 1.67502
R4089 VDD.n1551 VDD.n1550 1.67502
R4090 VDD.n1574 VDD.n1573 1.67502
R4091 VDD.n1571 VDD.n1570 1.67502
R4092 VDD.n1529 VDD.n1528 1.66715
R4093 VDD.n1538 VDD.n1536 1.66715
R4094 VDD.n1540 VDD.n1523 1.66715
R4095 VDD.n1563 VDD.n1561 1.66715
R4096 VDD.n1552 VDD.n1551 1.66715
R4097 VDD.n1573 VDD.n1572 1.66715
R4098 VDD.n1518 VDD.n1517 1.6669
R4099 VDD.n1565 VDD.n1548 1.6669
R4100 VDD.n2222 VDD.n1934 1.65646
R4101 VDD.n1934 VDD.n1933 1.58026
R4102 VDD.n2223 VDD.n17 1.47063
R4103 VDD.n2227 VDD.t1 1.30864
R4104 VDD.t1 VDD.n20 1.30849
R4105 VDD.n2224 VDD.n2222 1.3031
R4106 VDD.n1922 VDD.n1921 1.21575
R4107 VDD.n1923 VDD.n23 1.18096
R4108 VDD.n1153 VDD.n1152 1.15554
R4109 VDD.n2239 VDD.n2238 1.15554
R4110 VDD.n615 VDD.n610 1.13268
R4111 VDD.n826 VDD.n611 1.13268
R4112 VDD.n562 VDD.n377 1.13268
R4113 VDD.n593 VDD.n378 1.13268
R4114 VDD.n616 VDD.n615 1.13197
R4115 VDD.n589 VDD.n378 1.13197
R4116 VDD.n613 VDD.n612 1.1255
R4117 VDD.n825 VDD.n824 1.1255
R4118 VDD.n614 VDD.n613 1.1255
R4119 VDD.n824 VDD.n823 1.1255
R4120 VDD.n821 VDD.n611 1.1255
R4121 VDD.n380 VDD.n379 1.1255
R4122 VDD.n592 VDD.n591 1.1255
R4123 VDD.n381 VDD.n380 1.1255
R4124 VDD.n591 VDD.n590 1.1255
R4125 VDD.n563 VDD.n562 1.1255
R4126 VDD.n1510 VDD.n1509 1.11866
R4127 VDD.n1510 VDD.n1505 1.11866
R4128 VDD.n1510 VDD.n1504 1.11866
R4129 VDD.n1510 VDD.n1502 1.11866
R4130 VDD.n1510 VDD.n1501 1.11866
R4131 VDD.n1510 VDD.n1499 1.11866
R4132 VDD.n838 VDD.n832 1.0605
R4133 VDD.n836 VDD.n835 1.0605
R4134 VDD.n1084 VDD.n1083 1.04934
R4135 VDD.n986 VDD.n985 1.04934
R4136 VDD.n989 VDD.n988 1.04934
R4137 VDD.n992 VDD.n991 1.04934
R4138 VDD.n995 VDD.n994 1.04934
R4139 VDD.n998 VDD.n997 1.04934
R4140 VDD.n1001 VDD.n1000 1.04934
R4141 VDD.n1004 VDD.n1003 1.04934
R4142 VDD.n1007 VDD.n1006 1.04934
R4143 VDD.n1010 VDD.n1009 1.04934
R4144 VDD.n913 VDD.n910 1.04934
R4145 VDD.n926 VDD.n925 1.04934
R4146 VDD.n909 VDD.n906 1.04934
R4147 VDD.n938 VDD.n937 1.04934
R4148 VDD.n905 VDD.n902 1.04934
R4149 VDD.n950 VDD.n949 1.04934
R4150 VDD.n901 VDD.n898 1.04934
R4151 VDD.n962 VDD.n961 1.04934
R4152 VDD.n897 VDD.n894 1.04934
R4153 VDD.n974 VDD.n973 1.04934
R4154 VDD.n2182 VDD.n2181 1.04934
R4155 VDD.n2111 VDD.n1953 1.04934
R4156 VDD.n2114 VDD.n2113 1.04934
R4157 VDD.n2110 VDD.n1977 1.04934
R4158 VDD.n2126 VDD.n2125 1.04934
R4159 VDD.n1976 VDD.n1971 1.04934
R4160 VDD.n2138 VDD.n2137 1.04934
R4161 VDD.n2141 VDD.n2140 1.04934
R4162 VDD.n2081 VDD.n1970 1.04934
R4163 VDD.n2189 VDD.n2188 1.04934
R4164 VDD.n2202 VDD.n2201 1.04934
R4165 VDD.n2198 VDD.n2197 1.04934
R4166 VDD.n2107 VDD.n1948 1.04934
R4167 VDD.n2106 VDD.n2105 1.04934
R4168 VDD.n2103 VDD.n2102 1.04934
R4169 VDD.n2100 VDD.n2099 1.04934
R4170 VDD.n2097 VDD.n2096 1.04934
R4171 VDD.n1989 VDD.n1982 1.04934
R4172 VDD.n2058 VDD.n2057 1.04934
R4173 VDD.n2061 VDD.n2060 1.04934
R4174 VDD.n893 VDD.n892 1.04921
R4175 VDD.n1016 VDD.n1015 1.04921
R4176 VDD.n1013 VDD.n1012 1.04921
R4177 VDD.n1024 VDD.n1023 1.04921
R4178 VDD.n1025 VDD.n885 1.04921
R4179 VDD.n1036 VDD.n1035 1.04921
R4180 VDD.n1037 VDD.n881 1.04921
R4181 VDD.n1048 VDD.n1047 1.04921
R4182 VDD.n1049 VDD.n877 1.04921
R4183 VDD.n1060 VDD.n1059 1.04921
R4184 VDD.n1061 VDD.n873 1.04921
R4185 VDD.n1072 VDD.n1071 1.04921
R4186 VDD.n1073 VDD.n869 1.04921
R4187 VDD.n980 VDD.n979 1.04921
R4188 VDD.n895 VDD.n890 1.04921
R4189 VDD.n968 VDD.n967 1.04921
R4190 VDD.n899 VDD.n896 1.04921
R4191 VDD.n956 VDD.n955 1.04921
R4192 VDD.n903 VDD.n900 1.04921
R4193 VDD.n944 VDD.n943 1.04921
R4194 VDD.n907 VDD.n904 1.04921
R4195 VDD.n932 VDD.n931 1.04921
R4196 VDD.n911 VDD.n908 1.04921
R4197 VDD.n920 VDD.n919 1.04921
R4198 VDD.n1127 VDD.n1126 1.04921
R4199 VDD.n1124 VDD.n1123 1.04921
R4200 VDD.n1121 VDD.n1120 1.04921
R4201 VDD.n1118 VDD.n1117 1.04921
R4202 VDD.n1115 VDD.n1114 1.04921
R4203 VDD.n1112 VDD.n1111 1.04921
R4204 VDD.n1109 VDD.n1108 1.04921
R4205 VDD.n1106 VDD.n1105 1.04921
R4206 VDD.n1103 VDD.n1102 1.04921
R4207 VDD.n1100 VDD.n1099 1.04921
R4208 VDD.n1097 VDD.n1096 1.04921
R4209 VDD.n2064 VDD.n2063 1.04921
R4210 VDD.n2067 VDD.n1986 1.04921
R4211 VDD.n2080 VDD.n2079 1.04921
R4212 VDD.n2073 VDD.n2072 1.04921
R4213 VDD.n2074 VDD.n1984 1.04921
R4214 VDD.n2087 VDD.n2086 1.04921
R4215 VDD.n2090 VDD.n2089 1.04921
R4216 VDD.n2091 VDD.n1973 1.04921
R4217 VDD.n2132 VDD.n2131 1.04921
R4218 VDD.n1979 VDD.n1974 1.04921
R4219 VDD.n2120 VDD.n2119 1.04921
R4220 VDD.n1980 VDD.n1951 1.04921
R4221 VDD.n2192 VDD.n2191 1.04921
R4222 VDD.n1997 VDD.n1996 1.04921
R4223 VDD.n1998 VDD.n1991 1.04921
R4224 VDD.n2010 VDD.n2009 1.04921
R4225 VDD.n2052 VDD.n2051 1.04921
R4226 VDD.n2049 VDD.n2048 1.04921
R4227 VDD.n2018 VDD.n2011 1.04921
R4228 VDD.n2039 VDD.n2038 1.04921
R4229 VDD.n2025 VDD.n2024 1.04921
R4230 VDD.n2022 VDD.n2021 1.04921
R4231 VDD.n2019 VDD.n1944 1.04921
R4232 VDD.n2208 VDD.n2207 1.04921
R4233 VDD.n1945 VDD.n1942 1.04921
R4234 VDD.n2028 VDD.n2027 1.04921
R4235 VDD.n2031 VDD.n2030 1.04921
R4236 VDD.n2034 VDD.n2033 1.04921
R4237 VDD.n2026 VDD.n2017 1.04921
R4238 VDD.n2044 VDD.n2043 1.04921
R4239 VDD.n2016 VDD.n2015 1.04921
R4240 VDD.n2013 VDD.n2012 1.04921
R4241 VDD.n2005 VDD.n2004 1.04921
R4242 VDD.n2003 VDD.n2002 1.04921
R4243 VDD.n1994 VDD.n1993 1.04921
R4244 VDD.n1019 VDD.n887 1.0492
R4245 VDD.n1030 VDD.n1029 1.0492
R4246 VDD.n1031 VDD.n883 1.0492
R4247 VDD.n1042 VDD.n1041 1.0492
R4248 VDD.n1043 VDD.n879 1.0492
R4249 VDD.n1054 VDD.n1053 1.0492
R4250 VDD.n1055 VDD.n875 1.0492
R4251 VDD.n1066 VDD.n1065 1.0492
R4252 VDD.n1067 VDD.n871 1.0492
R4253 VDD.n1078 VDD.n1077 1.0492
R4254 VDD.n1079 VDD.n867 1.0492
R4255 VDD.n1962 VDD.n1961 1.0492
R4256 VDD.n1965 VDD.n1964 1.0492
R4257 VDD.n1968 VDD.n1967 1.0492
R4258 VDD.n2147 VDD.n2146 1.0492
R4259 VDD.n2160 VDD.n2159 1.0492
R4260 VDD.n2157 VDD.n2156 1.0492
R4261 VDD.n2154 VDD.n2153 1.0492
R4262 VDD.n2151 VDD.n2150 1.0492
R4263 VDD.n2148 VDD.n1954 1.0492
R4264 VDD.n2172 VDD.n2171 1.0492
R4265 VDD.n2176 VDD.n2175 1.0492
R4266 VDD.n1085 VDD.n866 1.00138
R4267 VDD.n983 VDD.n865 1.00138
R4268 VDD.n912 VDD.n864 1.00138
R4269 VDD.n914 VDD.n863 1.00138
R4270 VDD.n1130 VDD.n1129 1.00138
R4271 VDD.n2183 VDD.n1938 1.00138
R4272 VDD.n1952 VDD.n1939 1.00138
R4273 VDD.n2199 VDD.n1940 1.00138
R4274 VDD.n2209 VDD.n1941 1.00138
R4275 VDD.n2214 VDD.n2213 1.00138
R4276 VDD.n1090 VDD.n1089 1.00136
R4277 VDD.n2173 VDD.n1937 1.00136
R4278 VDD.n341 VDD.n340 0.930769
R4279 VDD.n340 VDD.n339 0.930769
R4280 VDD.n339 VDD.n338 0.930769
R4281 VDD.n338 VDD.n337 0.930769
R4282 VDD.n334 VDD.n333 0.930769
R4283 VDD.n333 VDD.n332 0.930769
R4284 VDD.n332 VDD.n331 0.930769
R4285 VDD.n331 VDD.n330 0.930769
R4286 VDD.n327 VDD.n326 0.930769
R4287 VDD.n326 VDD.n325 0.930769
R4288 VDD.n325 VDD.n324 0.930769
R4289 VDD.n324 VDD.n323 0.930769
R4290 VDD.n320 VDD.n319 0.930769
R4291 VDD.n319 VDD.n318 0.930769
R4292 VDD.n318 VDD.n317 0.930769
R4293 VDD.n317 VDD.n316 0.930769
R4294 VDD.n312 VDD.n311 0.930769
R4295 VDD.n311 VDD.n310 0.930769
R4296 VDD.n310 VDD.n309 0.930769
R4297 VDD.n309 VDD.n308 0.930769
R4298 VDD.n305 VDD.n304 0.930769
R4299 VDD.n304 VDD.n303 0.930769
R4300 VDD.n303 VDD.n302 0.930769
R4301 VDD.n302 VDD.n301 0.930769
R4302 VDD.n153 VDD.n152 0.930769
R4303 VDD.n152 VDD.n151 0.930769
R4304 VDD.n151 VDD.n150 0.930769
R4305 VDD.n150 VDD.n149 0.930769
R4306 VDD.n293 VDD.n292 0.930769
R4307 VDD.n292 VDD.n291 0.930769
R4308 VDD.n291 VDD.n290 0.930769
R4309 VDD.n290 VDD.n289 0.930769
R4310 VDD.n286 VDD.n285 0.930769
R4311 VDD.n285 VDD.n284 0.930769
R4312 VDD.n284 VDD.n283 0.930769
R4313 VDD.n283 VDD.n282 0.930769
R4314 VDD.n279 VDD.n278 0.930769
R4315 VDD.n278 VDD.n277 0.930769
R4316 VDD.n277 VDD.n276 0.930769
R4317 VDD.n276 VDD.n275 0.930769
R4318 VDD.n271 VDD.n270 0.930769
R4319 VDD.n270 VDD.n269 0.930769
R4320 VDD.n269 VDD.n268 0.930769
R4321 VDD.n268 VDD.n267 0.930769
R4322 VDD.n264 VDD.n263 0.930769
R4323 VDD.n263 VDD.n262 0.930769
R4324 VDD.n262 VDD.n261 0.930769
R4325 VDD.n261 VDD.n260 0.930769
R4326 VDD.n168 VDD.n167 0.930769
R4327 VDD.n167 VDD.n166 0.930769
R4328 VDD.n166 VDD.n165 0.930769
R4329 VDD.n165 VDD.n164 0.930769
R4330 VDD.n161 VDD.n160 0.930769
R4331 VDD.n160 VDD.n159 0.930769
R4332 VDD.n159 VDD.n158 0.930769
R4333 VDD.n158 VDD.n157 0.930769
R4334 VDD.n252 VDD.n251 0.930769
R4335 VDD.n251 VDD.n250 0.930769
R4336 VDD.n250 VDD.n249 0.930769
R4337 VDD.n249 VDD.n248 0.930769
R4338 VDD.n245 VDD.n244 0.930769
R4339 VDD.n244 VDD.n243 0.930769
R4340 VDD.n243 VDD.n242 0.930769
R4341 VDD.n242 VDD.n241 0.930769
R4342 VDD.n238 VDD.n237 0.930769
R4343 VDD.n237 VDD.n236 0.930769
R4344 VDD.n236 VDD.n235 0.930769
R4345 VDD.n235 VDD.n234 0.930769
R4346 VDD.n230 VDD.n229 0.930769
R4347 VDD.n229 VDD.n228 0.930769
R4348 VDD.n228 VDD.n227 0.930769
R4349 VDD.n227 VDD.n226 0.930769
R4350 VDD.n223 VDD.n222 0.930769
R4351 VDD.n222 VDD.n221 0.930769
R4352 VDD.n221 VDD.n220 0.930769
R4353 VDD.n220 VDD.n219 0.930769
R4354 VDD.n176 VDD.n175 0.930769
R4355 VDD.n175 VDD.n174 0.930769
R4356 VDD.n174 VDD.n173 0.930769
R4357 VDD.n173 VDD.n172 0.930769
R4358 VDD.n212 VDD.n211 0.930769
R4359 VDD.n211 VDD.n210 0.930769
R4360 VDD.n210 VDD.n209 0.930769
R4361 VDD.n209 VDD.n208 0.930769
R4362 VDD.n205 VDD.n204 0.930769
R4363 VDD.n204 VDD.n203 0.930769
R4364 VDD.n203 VDD.n202 0.930769
R4365 VDD.n202 VDD.n201 0.930769
R4366 VDD.n198 VDD.n197 0.930769
R4367 VDD.n197 VDD.n196 0.930769
R4368 VDD.n196 VDD.n195 0.930769
R4369 VDD.n195 VDD.n194 0.930769
R4370 VDD.n191 VDD.n190 0.930769
R4371 VDD.n190 VDD.n189 0.930769
R4372 VDD.n189 VDD.n188 0.930769
R4373 VDD.n188 VDD.n187 0.930769
R4374 VDD.n184 VDD.n183 0.930769
R4375 VDD.n183 VDD.n182 0.930769
R4376 VDD.n182 VDD.n181 0.930769
R4377 VDD.n181 VDD.n180 0.930769
R4378 VDD VDD.n829 0.858516
R4379 VDD.n841 VDD.n840 0.852589
R4380 VDD.n803 VDD.t94 0.760677
R4381 VDD.n585 VDD.t613 0.760677
R4382 VDD.n1933 VDD.n1932 0.711375
R4383 VDD.n216 VDD.n179 0.700172
R4384 VDD.n217 VDD.n216 0.700172
R4385 VDD.n217 VDD.n171 0.700172
R4386 VDD.n256 VDD.n171 0.700172
R4387 VDD.n258 VDD.n256 0.700172
R4388 VDD.n298 VDD.n156 0.700172
R4389 VDD.n299 VDD.n298 0.700172
R4390 VDD.n299 VDD.n148 0.700172
R4391 VDD.n344 VDD.n148 0.700172
R4392 VDD.n137 VDD.n136 0.700172
R4393 VDD.n138 VDD.n137 0.700172
R4394 VDD.n170 VDD.n138 0.700172
R4395 VDD.n170 VDD.n141 0.700172
R4396 VDD.n142 VDD.n141 0.700172
R4397 VDD.n143 VDD.n142 0.700172
R4398 VDD.n297 VDD.n143 0.700172
R4399 VDD.n297 VDD.n146 0.700172
R4400 VDD.n147 VDD.n146 0.700172
R4401 VDD.n345 VDD.n147 0.700172
R4402 VDD.n361 VDD.n360 0.688887
R4403 VDD.n360 VDD.n359 0.688887
R4404 VDD.n359 VDD.n139 0.688887
R4405 VDD.n355 VDD.n139 0.688887
R4406 VDD.n355 VDD.n354 0.688887
R4407 VDD.n354 VDD.n353 0.688887
R4408 VDD.n353 VDD.n144 0.688887
R4409 VDD.n349 VDD.n144 0.688887
R4410 VDD.n349 VDD.n348 0.688887
R4411 VDD.n348 VDD.n347 0.688887
R4412 VDD.n1923 VDD.n1922 0.6528
R4413 VDD.n1131 VDD.n1094 0.612309
R4414 VDD.n1094 VDD.n1093 0.612309
R4415 VDD.n1093 VDD.n1092 0.612309
R4416 VDD.n1092 VDD.n1091 0.612309
R4417 VDD.n2216 VDD.n2215 0.612309
R4418 VDD.n2217 VDD.n2216 0.612309
R4419 VDD.n2218 VDD.n2217 0.612309
R4420 VDD.n2219 VDD.n2218 0.612309
R4421 VDD.n810 VDD.n809 0.604502
R4422 VDD.n806 VDD.n805 0.604502
R4423 VDD.n579 VDD.n578 0.604502
R4424 VDD.n583 VDD.n582 0.604502
R4425 VDD.n805 VDD.n804 0.603833
R4426 VDD.n800 VDD.n798 0.6005
R4427 VDD.n799 VDD.n797 0.6005
R4428 VDD.n811 VDD.n810 0.6005
R4429 VDD.n807 VDD.n798 0.6005
R4430 VDD.n808 VDD.n797 0.6005
R4431 VDD.n585 VDD.n384 0.6005
R4432 VDD.n585 VDD.n584 0.6005
R4433 VDD.n575 VDD.n574 0.6005
R4434 VDD.n577 VDD.n576 0.6005
R4435 VDD.n578 VDD.n384 0.6005
R4436 VDD.n584 VDD.n583 0.6005
R4437 VDD.n581 VDD.n575 0.6005
R4438 VDD.n580 VDD.n577 0.6005
R4439 VDD.n1932 VDD.n1927 0.598832
R4440 VDD.n1930 VDD.n1929 0.598832
R4441 VDD.n1931 VDD.n1928 0.598699
R4442 VDD.n621 VDD.t86 0.592113
R4443 VDD.n678 VDD.t88 0.592113
R4444 VDD.n736 VDD.t90 0.592113
R4445 VDD.n794 VDD.t92 0.592113
R4446 VDD.n385 VDD.t614 0.592113
R4447 VDD.n387 VDD.t616 0.592113
R4448 VDD.n389 VDD.t618 0.592113
R4449 VDD.n569 VDD.t620 0.592113
R4450 VDD.n621 VDD.t87 0.59207
R4451 VDD.n678 VDD.t89 0.59207
R4452 VDD.n736 VDD.t91 0.59207
R4453 VDD.n794 VDD.t93 0.59207
R4454 VDD.n385 VDD.t615 0.59207
R4455 VDD.n387 VDD.t617 0.59207
R4456 VDD.n389 VDD.t619 0.59207
R4457 VDD.n569 VDD.t621 0.59207
R4458 VDD.n567 VDD.n566 0.573973
R4459 VDD.n818 VDD.n817 0.572734
R4460 VDD.n827 VDD.n610 0.570183
R4461 VDD.n827 VDD.n826 0.570183
R4462 VDD.n594 VDD.n377 0.570183
R4463 VDD.n594 VDD.n593 0.570183
R4464 VDD.n822 VDD.n617 0.560516
R4465 VDD.n617 VDD.n616 0.560516
R4466 VDD.n589 VDD.n588 0.560516
R4467 VDD.n588 VDD.n382 0.560516
R4468 VDD.n1539 VDD.n1524 0.543586
R4469 VDD.n1524 VDD.n1513 0.543586
R4470 VDD.n1544 VDD.n1543 0.543586
R4471 VDD.n1545 VDD.n1544 0.543586
R4472 VDD.n1549 VDD.n1514 0.543586
R4473 VDD.n1564 VDD.n1549 0.543586
R4474 VDD.n1576 VDD.n1569 0.543586
R4475 VDD.n1569 VDD.n1568 0.543586
R4476 VDD.n1555 VDD.n1511 0.543586
R4477 VDD.n1558 VDD.n1555 0.543586
R4478 VDD.n1533 VDD.n1532 0.543586
R4479 VDD.n1532 VDD.n1512 0.543586
R4480 VDD.n257 VDD.n156 0.530664
R4481 VDD.n801 VDD.t77 0.521925
R4482 VDD.n587 VDD.t597 0.521925
R4483 VDD.n817 VDD.t70 0.520854
R4484 VDD.n567 VDD.t604 0.520854
R4485 VDD.n816 VDD.t78 0.514042
R4486 VDD.n802 VDD.t85 0.514042
R4487 VDD.n586 VDD.t605 0.514042
R4488 VDD.n568 VDD.t612 0.514042
R4489 VDD.n342 VDD.n341 0.513914
R4490 VDD.n335 VDD.n334 0.513914
R4491 VDD.n328 VDD.n327 0.513914
R4492 VDD.n321 VDD.n320 0.513914
R4493 VDD.n313 VDD.n312 0.513914
R4494 VDD.n306 VDD.n305 0.513914
R4495 VDD.n154 VDD.n153 0.513914
R4496 VDD.n294 VDD.n293 0.513914
R4497 VDD.n287 VDD.n286 0.513914
R4498 VDD.n280 VDD.n279 0.513914
R4499 VDD.n272 VDD.n271 0.513914
R4500 VDD.n265 VDD.n264 0.513914
R4501 VDD.n169 VDD.n168 0.513914
R4502 VDD.n162 VDD.n161 0.513914
R4503 VDD.n253 VDD.n252 0.513914
R4504 VDD.n246 VDD.n245 0.513914
R4505 VDD.n239 VDD.n238 0.513914
R4506 VDD.n231 VDD.n230 0.513914
R4507 VDD.n224 VDD.n223 0.513914
R4508 VDD.n177 VDD.n176 0.513914
R4509 VDD.n213 VDD.n212 0.513914
R4510 VDD.n206 VDD.n205 0.513914
R4511 VDD.n199 VDD.n198 0.513914
R4512 VDD.n192 VDD.n191 0.513914
R4513 VDD.n185 VDD.n184 0.513914
R4514 VDD.n2229 VDD.n2228 0.487174
R4515 VDD.n817 VDD.n816 0.480486
R4516 VDD.n568 VDD.n567 0.480486
R4517 VDD.n802 VDD.n801 0.47938
R4518 VDD.n587 VDD.n586 0.47938
R4519 VDD.n1020 VDD.n1019 0.476236
R4520 VDD.n1029 VDD.n1028 0.476236
R4521 VDD.n1032 VDD.n1031 0.476236
R4522 VDD.n1041 VDD.n1040 0.476236
R4523 VDD.n1044 VDD.n1043 0.476236
R4524 VDD.n1053 VDD.n1052 0.476236
R4525 VDD.n1056 VDD.n1055 0.476236
R4526 VDD.n1065 VDD.n1064 0.476236
R4527 VDD.n1068 VDD.n1067 0.476236
R4528 VDD.n1077 VDD.n1076 0.476236
R4529 VDD.n1080 VDD.n1079 0.476236
R4530 VDD.n1089 VDD.n1088 0.476236
R4531 VDD.n1961 VDD.n1960 0.476236
R4532 VDD.n1964 VDD.n1963 0.476236
R4533 VDD.n1967 VDD.n1966 0.476236
R4534 VDD.n2146 VDD.n2145 0.476236
R4535 VDD.n2161 VDD.n2160 0.476236
R4536 VDD.n2158 VDD.n2157 0.476236
R4537 VDD.n2155 VDD.n2154 0.476236
R4538 VDD.n2152 VDD.n2151 0.476236
R4539 VDD.n2149 VDD.n2148 0.476236
R4540 VDD.n2171 VDD.n2170 0.476236
R4541 VDD.n2177 VDD.n2176 0.476236
R4542 VDD.n2174 VDD.n2173 0.476236
R4543 VDD.n892 VDD.n891 0.476103
R4544 VDD.n1017 VDD.n1016 0.476103
R4545 VDD.n1014 VDD.n1013 0.476103
R4546 VDD.n1023 VDD.n1022 0.476103
R4547 VDD.n1026 VDD.n1025 0.476103
R4548 VDD.n1035 VDD.n1034 0.476103
R4549 VDD.n1038 VDD.n1037 0.476103
R4550 VDD.n1047 VDD.n1046 0.476103
R4551 VDD.n1050 VDD.n1049 0.476103
R4552 VDD.n1059 VDD.n1058 0.476103
R4553 VDD.n1062 VDD.n1061 0.476103
R4554 VDD.n1071 VDD.n1070 0.476103
R4555 VDD.n1074 VDD.n1073 0.476103
R4556 VDD.n1086 VDD.n1085 0.476103
R4557 VDD.n1083 VDD.n1082 0.476103
R4558 VDD.n984 VDD.n983 0.476103
R4559 VDD.n987 VDD.n986 0.476103
R4560 VDD.n990 VDD.n989 0.476103
R4561 VDD.n993 VDD.n992 0.476103
R4562 VDD.n996 VDD.n995 0.476103
R4563 VDD.n999 VDD.n998 0.476103
R4564 VDD.n1002 VDD.n1001 0.476103
R4565 VDD.n1005 VDD.n1004 0.476103
R4566 VDD.n1008 VDD.n1007 0.476103
R4567 VDD.n1011 VDD.n1010 0.476103
R4568 VDD.n981 VDD.n980 0.476103
R4569 VDD.n978 VDD.n890 0.476103
R4570 VDD.n969 VDD.n968 0.476103
R4571 VDD.n966 VDD.n896 0.476103
R4572 VDD.n957 VDD.n956 0.476103
R4573 VDD.n954 VDD.n900 0.476103
R4574 VDD.n945 VDD.n944 0.476103
R4575 VDD.n942 VDD.n904 0.476103
R4576 VDD.n933 VDD.n932 0.476103
R4577 VDD.n930 VDD.n908 0.476103
R4578 VDD.n921 VDD.n920 0.476103
R4579 VDD.n918 VDD.n912 0.476103
R4580 VDD.n915 VDD.n914 0.476103
R4581 VDD.n924 VDD.n910 0.476103
R4582 VDD.n927 VDD.n926 0.476103
R4583 VDD.n936 VDD.n906 0.476103
R4584 VDD.n939 VDD.n938 0.476103
R4585 VDD.n948 VDD.n902 0.476103
R4586 VDD.n951 VDD.n950 0.476103
R4587 VDD.n960 VDD.n898 0.476103
R4588 VDD.n963 VDD.n962 0.476103
R4589 VDD.n972 VDD.n894 0.476103
R4590 VDD.n975 VDD.n974 0.476103
R4591 VDD.n1129 VDD.n1128 0.476103
R4592 VDD.n1126 VDD.n1125 0.476103
R4593 VDD.n1123 VDD.n1122 0.476103
R4594 VDD.n1120 VDD.n1119 0.476103
R4595 VDD.n1117 VDD.n1116 0.476103
R4596 VDD.n1114 VDD.n1113 0.476103
R4597 VDD.n1111 VDD.n1110 0.476103
R4598 VDD.n1108 VDD.n1107 0.476103
R4599 VDD.n1105 VDD.n1104 0.476103
R4600 VDD.n1102 VDD.n1101 0.476103
R4601 VDD.n1099 VDD.n1098 0.476103
R4602 VDD.n1096 VDD.n1095 0.476103
R4603 VDD.n2065 VDD.n2064 0.476103
R4604 VDD.n2068 VDD.n2067 0.476103
R4605 VDD.n2079 VDD.n2078 0.476103
R4606 VDD.n2184 VDD.n2183 0.476103
R4607 VDD.n2181 VDD.n2180 0.476103
R4608 VDD.n2112 VDD.n2111 0.476103
R4609 VDD.n2115 VDD.n2114 0.476103
R4610 VDD.n2124 VDD.n1977 0.476103
R4611 VDD.n2127 VDD.n2126 0.476103
R4612 VDD.n2136 VDD.n1971 0.476103
R4613 VDD.n2139 VDD.n2138 0.476103
R4614 VDD.n2142 VDD.n2141 0.476103
R4615 VDD.n2082 VDD.n2081 0.476103
R4616 VDD.n2072 VDD.n2071 0.476103
R4617 VDD.n2075 VDD.n2074 0.476103
R4618 VDD.n2086 VDD.n2085 0.476103
R4619 VDD.n2089 VDD.n2088 0.476103
R4620 VDD.n2092 VDD.n2091 0.476103
R4621 VDD.n2133 VDD.n2132 0.476103
R4622 VDD.n2130 VDD.n1974 0.476103
R4623 VDD.n2121 VDD.n2120 0.476103
R4624 VDD.n2118 VDD.n1980 0.476103
R4625 VDD.n2193 VDD.n2192 0.476103
R4626 VDD.n2187 VDD.n1952 0.476103
R4627 VDD.n2190 VDD.n2189 0.476103
R4628 VDD.n2200 VDD.n2199 0.476103
R4629 VDD.n2203 VDD.n2202 0.476103
R4630 VDD.n2197 VDD.n2196 0.476103
R4631 VDD.n2108 VDD.n2107 0.476103
R4632 VDD.n2105 VDD.n2104 0.476103
R4633 VDD.n2102 VDD.n2101 0.476103
R4634 VDD.n2099 VDD.n2098 0.476103
R4635 VDD.n2096 VDD.n2095 0.476103
R4636 VDD.n2056 VDD.n1989 0.476103
R4637 VDD.n2059 VDD.n2058 0.476103
R4638 VDD.n2062 VDD.n2061 0.476103
R4639 VDD.n1996 VDD.n1995 0.476103
R4640 VDD.n1999 VDD.n1998 0.476103
R4641 VDD.n2009 VDD.n2008 0.476103
R4642 VDD.n2053 VDD.n2052 0.476103
R4643 VDD.n2050 VDD.n2049 0.476103
R4644 VDD.n2047 VDD.n2011 0.476103
R4645 VDD.n2040 VDD.n2039 0.476103
R4646 VDD.n2037 VDD.n2025 0.476103
R4647 VDD.n2023 VDD.n2022 0.476103
R4648 VDD.n2020 VDD.n2019 0.476103
R4649 VDD.n2207 VDD.n2206 0.476103
R4650 VDD.n2210 VDD.n2209 0.476103
R4651 VDD.n2213 VDD.n2212 0.476103
R4652 VDD.n1946 VDD.n1945 0.476103
R4653 VDD.n2029 VDD.n2028 0.476103
R4654 VDD.n2032 VDD.n2031 0.476103
R4655 VDD.n2035 VDD.n2034 0.476103
R4656 VDD.n2042 VDD.n2017 0.476103
R4657 VDD.n2045 VDD.n2044 0.476103
R4658 VDD.n2015 VDD.n2014 0.476103
R4659 VDD.n2012 VDD.n1990 0.476103
R4660 VDD.n2006 VDD.n2005 0.476103
R4661 VDD.n2002 VDD.n2001 0.476103
R4662 VDD.n1993 VDD.n1992 0.476103
R4663 VDD.n842 VDD.n362 0.465591
R4664 VDD VDD.n0 0.456591
R4665 VDD.n1761 VDD.n1760 0.4505
R4666 VDD.n1661 VDD.n1660 0.4505
R4667 VDD.n1920 VDD.n1919 0.4505
R4668 VDD.n1191 VDD.n1190 0.4505
R4669 VDD.n1134 VDD.n1133 0.4505
R4670 VDD.n1144 VDD.n1143 0.4505
R4671 VDD.n2232 VDD.n2231 0.4505
R4672 VDD.n2222 VDD.n2221 0.4505
R4673 VDD.n186 VDD.n179 0.4505
R4674 VDD.n216 VDD.n215 0.4505
R4675 VDD.n218 VDD.n217 0.4505
R4676 VDD.n233 VDD.n171 0.4505
R4677 VDD.n256 VDD.n255 0.4505
R4678 VDD.n259 VDD.n258 0.4505
R4679 VDD.n274 VDD.n156 0.4505
R4680 VDD.n298 VDD.n296 0.4505
R4681 VDD.n300 VDD.n299 0.4505
R4682 VDD.n315 VDD.n148 0.4505
R4683 VDD.n344 VDD.n343 0.4505
R4684 VDD.n179 VDD.n136 0.4505
R4685 VDD.n216 VDD.n137 0.4505
R4686 VDD.n217 VDD.n138 0.4505
R4687 VDD.n171 VDD.n170 0.4505
R4688 VDD.n256 VDD.n141 0.4505
R4689 VDD.n258 VDD.n142 0.4505
R4690 VDD.n156 VDD.n143 0.4505
R4691 VDD.n298 VDD.n297 0.4505
R4692 VDD.n299 VDD.n146 0.4505
R4693 VDD.n148 VDD.n147 0.4505
R4694 VDD.n345 VDD.n344 0.4505
R4695 VDD.n361 VDD.n136 0.4505
R4696 VDD.n360 VDD.n137 0.4505
R4697 VDD.n359 VDD.n138 0.4505
R4698 VDD.n170 VDD.n139 0.4505
R4699 VDD.n355 VDD.n141 0.4505
R4700 VDD.n354 VDD.n142 0.4505
R4701 VDD.n353 VDD.n143 0.4505
R4702 VDD.n297 VDD.n144 0.4505
R4703 VDD.n349 VDD.n146 0.4505
R4704 VDD.n348 VDD.n147 0.4505
R4705 VDD.n347 VDD.n345 0.4505
R4706 VDD.n975 VDD.n893 0.442299
R4707 VDD.n1015 VDD.n1014 0.442299
R4708 VDD.n1012 VDD.n1011 0.442299
R4709 VDD.n1026 VDD.n1024 0.442299
R4710 VDD.n1034 VDD.n885 0.442299
R4711 VDD.n1038 VDD.n1036 0.442299
R4712 VDD.n1046 VDD.n881 0.442299
R4713 VDD.n1050 VDD.n1048 0.442299
R4714 VDD.n1058 VDD.n877 0.442299
R4715 VDD.n1062 VDD.n1060 0.442299
R4716 VDD.n1070 VDD.n873 0.442299
R4717 VDD.n1074 VDD.n1072 0.442299
R4718 VDD.n1082 VDD.n869 0.442299
R4719 VDD.n979 VDD.n978 0.442299
R4720 VDD.n969 VDD.n895 0.442299
R4721 VDD.n967 VDD.n966 0.442299
R4722 VDD.n957 VDD.n899 0.442299
R4723 VDD.n955 VDD.n954 0.442299
R4724 VDD.n945 VDD.n903 0.442299
R4725 VDD.n943 VDD.n942 0.442299
R4726 VDD.n933 VDD.n907 0.442299
R4727 VDD.n931 VDD.n930 0.442299
R4728 VDD.n921 VDD.n911 0.442299
R4729 VDD.n919 VDD.n918 0.442299
R4730 VDD.n1128 VDD.n1127 0.442299
R4731 VDD.n1125 VDD.n1124 0.442299
R4732 VDD.n1122 VDD.n1121 0.442299
R4733 VDD.n1119 VDD.n1118 0.442299
R4734 VDD.n1116 VDD.n1115 0.442299
R4735 VDD.n1113 VDD.n1112 0.442299
R4736 VDD.n1110 VDD.n1109 0.442299
R4737 VDD.n1107 VDD.n1106 0.442299
R4738 VDD.n1104 VDD.n1103 0.442299
R4739 VDD.n1101 VDD.n1100 0.442299
R4740 VDD.n1098 VDD.n1097 0.442299
R4741 VDD.n2063 VDD.n2062 0.442299
R4742 VDD.n2078 VDD.n1986 0.442299
R4743 VDD.n2082 VDD.n2080 0.442299
R4744 VDD.n2075 VDD.n2073 0.442299
R4745 VDD.n2085 VDD.n1984 0.442299
R4746 VDD.n2088 VDD.n2087 0.442299
R4747 VDD.n2092 VDD.n2090 0.442299
R4748 VDD.n2133 VDD.n1973 0.442299
R4749 VDD.n2131 VDD.n2130 0.442299
R4750 VDD.n2121 VDD.n1979 0.442299
R4751 VDD.n2119 VDD.n2118 0.442299
R4752 VDD.n2193 VDD.n1951 0.442299
R4753 VDD.n2191 VDD.n2190 0.442299
R4754 VDD.n1999 VDD.n1997 0.442299
R4755 VDD.n2008 VDD.n1991 0.442299
R4756 VDD.n2053 VDD.n2010 0.442299
R4757 VDD.n2051 VDD.n2050 0.442299
R4758 VDD.n2048 VDD.n2047 0.442299
R4759 VDD.n2040 VDD.n2018 0.442299
R4760 VDD.n2038 VDD.n2037 0.442299
R4761 VDD.n2024 VDD.n2023 0.442299
R4762 VDD.n2021 VDD.n2020 0.442299
R4763 VDD.n2206 VDD.n1944 0.442299
R4764 VDD.n2210 VDD.n2208 0.442299
R4765 VDD.n2212 VDD.n1942 0.442299
R4766 VDD.n2027 VDD.n1946 0.442299
R4767 VDD.n2030 VDD.n2029 0.442299
R4768 VDD.n2033 VDD.n2032 0.442299
R4769 VDD.n2035 VDD.n2026 0.442299
R4770 VDD.n2043 VDD.n2042 0.442299
R4771 VDD.n2045 VDD.n2016 0.442299
R4772 VDD.n2014 VDD.n2013 0.442299
R4773 VDD.n2004 VDD.n1990 0.442299
R4774 VDD.n2006 VDD.n2003 0.442299
R4775 VDD.n2001 VDD.n1994 0.442299
R4776 VDD.n1086 VDD.n1084 0.442162
R4777 VDD.n985 VDD.n984 0.442162
R4778 VDD.n988 VDD.n987 0.442162
R4779 VDD.n991 VDD.n990 0.442162
R4780 VDD.n994 VDD.n993 0.442162
R4781 VDD.n997 VDD.n996 0.442162
R4782 VDD.n1000 VDD.n999 0.442162
R4783 VDD.n1003 VDD.n1002 0.442162
R4784 VDD.n1006 VDD.n1005 0.442162
R4785 VDD.n1009 VDD.n1008 0.442162
R4786 VDD.n915 VDD.n913 0.442162
R4787 VDD.n925 VDD.n924 0.442162
R4788 VDD.n927 VDD.n909 0.442162
R4789 VDD.n937 VDD.n936 0.442162
R4790 VDD.n939 VDD.n905 0.442162
R4791 VDD.n949 VDD.n948 0.442162
R4792 VDD.n951 VDD.n901 0.442162
R4793 VDD.n961 VDD.n960 0.442162
R4794 VDD.n963 VDD.n897 0.442162
R4795 VDD.n973 VDD.n972 0.442162
R4796 VDD.n1028 VDD.n887 0.442162
R4797 VDD.n1032 VDD.n1030 0.442162
R4798 VDD.n1040 VDD.n883 0.442162
R4799 VDD.n1044 VDD.n1042 0.442162
R4800 VDD.n1052 VDD.n879 0.442162
R4801 VDD.n1056 VDD.n1054 0.442162
R4802 VDD.n1064 VDD.n875 0.442162
R4803 VDD.n1068 VDD.n1066 0.442162
R4804 VDD.n1076 VDD.n871 0.442162
R4805 VDD.n1080 VDD.n1078 0.442162
R4806 VDD.n1088 VDD.n867 0.442162
R4807 VDD.n2184 VDD.n2182 0.442162
R4808 VDD.n2180 VDD.n1953 0.442162
R4809 VDD.n2113 VDD.n2112 0.442162
R4810 VDD.n2115 VDD.n2110 0.442162
R4811 VDD.n2125 VDD.n2124 0.442162
R4812 VDD.n2127 VDD.n1976 0.442162
R4813 VDD.n2137 VDD.n2136 0.442162
R4814 VDD.n2140 VDD.n2139 0.442162
R4815 VDD.n2142 VDD.n1970 0.442162
R4816 VDD.n2188 VDD.n2187 0.442162
R4817 VDD.n2201 VDD.n2200 0.442162
R4818 VDD.n2203 VDD.n2198 0.442162
R4819 VDD.n2196 VDD.n1948 0.442162
R4820 VDD.n2108 VDD.n2106 0.442162
R4821 VDD.n2104 VDD.n2103 0.442162
R4822 VDD.n2101 VDD.n2100 0.442162
R4823 VDD.n2098 VDD.n2097 0.442162
R4824 VDD.n2095 VDD.n1982 0.442162
R4825 VDD.n2057 VDD.n2056 0.442162
R4826 VDD.n2060 VDD.n2059 0.442162
R4827 VDD.n1963 VDD.n1962 0.442162
R4828 VDD.n1966 VDD.n1965 0.442162
R4829 VDD.n2145 VDD.n1968 0.442162
R4830 VDD.n2161 VDD.n2147 0.442162
R4831 VDD.n2159 VDD.n2158 0.442162
R4832 VDD.n2156 VDD.n2155 0.442162
R4833 VDD.n2153 VDD.n2152 0.442162
R4834 VDD.n2150 VDD.n2149 0.442162
R4835 VDD.n2170 VDD.n1954 0.442162
R4836 VDD.n2177 VDD.n2172 0.442162
R4837 VDD.n2175 VDD.n2174 0.442162
R4838 VDD.n605 VDD.n604 0.429881
R4839 VDD.n368 VDD.n367 0.429881
R4840 VDD.n603 VDD.n599 0.416418
R4841 VDD.n601 VDD.n600 0.416418
R4842 VDD.n372 VDD.n371 0.416418
R4843 VDD.n366 VDD.n365 0.416418
R4844 VDD.n928 VDD.n860 0.402
R4845 VDD.n929 VDD.n928 0.402
R4846 VDD.n929 VDD.n872 0.402
R4847 VDD.n1075 VDD.n872 0.402
R4848 VDD.n935 VDD.n859 0.402
R4849 VDD.n935 VDD.n934 0.402
R4850 VDD.n934 VDD.n874 0.402
R4851 VDD.n1069 VDD.n874 0.402
R4852 VDD.n940 VDD.n858 0.402
R4853 VDD.n941 VDD.n940 0.402
R4854 VDD.n941 VDD.n876 0.402
R4855 VDD.n1063 VDD.n876 0.402
R4856 VDD.n947 VDD.n857 0.402
R4857 VDD.n947 VDD.n946 0.402
R4858 VDD.n946 VDD.n878 0.402
R4859 VDD.n1057 VDD.n878 0.402
R4860 VDD.n952 VDD.n856 0.402
R4861 VDD.n953 VDD.n952 0.402
R4862 VDD.n953 VDD.n880 0.402
R4863 VDD.n1051 VDD.n880 0.402
R4864 VDD.n959 VDD.n855 0.402
R4865 VDD.n959 VDD.n958 0.402
R4866 VDD.n958 VDD.n882 0.402
R4867 VDD.n1045 VDD.n882 0.402
R4868 VDD.n964 VDD.n854 0.402
R4869 VDD.n965 VDD.n964 0.402
R4870 VDD.n965 VDD.n884 0.402
R4871 VDD.n1039 VDD.n884 0.402
R4872 VDD.n923 VDD.n861 0.402
R4873 VDD.n923 VDD.n922 0.402
R4874 VDD.n922 VDD.n870 0.402
R4875 VDD.n1081 VDD.n870 0.402
R4876 VDD.n971 VDD.n853 0.402
R4877 VDD.n971 VDD.n970 0.402
R4878 VDD.n970 VDD.n886 0.402
R4879 VDD.n1033 VDD.n886 0.402
R4880 VDD.n916 VDD.n862 0.402
R4881 VDD.n917 VDD.n916 0.402
R4882 VDD.n917 VDD.n868 0.402
R4883 VDD.n1087 VDD.n868 0.402
R4884 VDD.n976 VDD.n852 0.402
R4885 VDD.n977 VDD.n976 0.402
R4886 VDD.n977 VDD.n888 0.402
R4887 VDD.n1027 VDD.n888 0.402
R4888 VDD.n889 VDD.n851 0.402
R4889 VDD.n982 VDD.n889 0.402
R4890 VDD.n1018 VDD.n982 0.402
R4891 VDD.n1021 VDD.n1018 0.402
R4892 VDD.n1931 VDD.n1930 0.402
R4893 VDD.n1932 VDD.n1931 0.402
R4894 VDD.n2055 VDD.n2054 0.402
R4895 VDD.n2055 VDD.n1969 0.402
R4896 VDD.n2143 VDD.n1969 0.402
R4897 VDD.n2144 VDD.n2143 0.402
R4898 VDD.n2094 VDD.n1983 0.402
R4899 VDD.n2094 VDD.n2093 0.402
R4900 VDD.n2093 VDD.n1959 0.402
R4901 VDD.n2162 VDD.n1959 0.402
R4902 VDD.n2046 VDD.n1972 0.402
R4903 VDD.n2134 VDD.n1972 0.402
R4904 VDD.n2135 VDD.n2134 0.402
R4905 VDD.n2135 VDD.n1958 0.402
R4906 VDD.n2041 VDD.n1975 0.402
R4907 VDD.n2129 VDD.n1975 0.402
R4908 VDD.n2129 VDD.n2128 0.402
R4909 VDD.n2128 VDD.n1957 0.402
R4910 VDD.n2036 VDD.n1978 0.402
R4911 VDD.n2122 VDD.n1978 0.402
R4912 VDD.n2123 VDD.n2122 0.402
R4913 VDD.n2123 VDD.n1956 0.402
R4914 VDD.n2109 VDD.n1981 0.402
R4915 VDD.n2117 VDD.n2109 0.402
R4916 VDD.n2117 VDD.n2116 0.402
R4917 VDD.n2116 VDD.n1955 0.402
R4918 VDD.n2195 VDD.n1949 0.402
R4919 VDD.n2195 VDD.n2194 0.402
R4920 VDD.n2194 VDD.n1950 0.402
R4921 VDD.n2169 VDD.n1950 0.402
R4922 VDD.n2007 VDD.n1985 0.402
R4923 VDD.n2084 VDD.n1985 0.402
R4924 VDD.n2084 VDD.n2083 0.402
R4925 VDD.n2083 VDD.n13 0.402
R4926 VDD.n2205 VDD.n2204 0.402
R4927 VDD.n2204 VDD.n1947 0.402
R4928 VDD.n2179 VDD.n1947 0.402
R4929 VDD.n2179 VDD.n2178 0.402
R4930 VDD.n2000 VDD.n1987 0.402
R4931 VDD.n2076 VDD.n1987 0.402
R4932 VDD.n2077 VDD.n2076 0.402
R4933 VDD.n2077 VDD.n12 0.402
R4934 VDD.n2211 VDD.n1943 0.402
R4935 VDD.n2186 VDD.n1943 0.402
R4936 VDD.n2186 VDD.n2185 0.402
R4937 VDD.n2185 VDD.n1936 0.402
R4938 VDD.n2066 VDD.n1988 0.402
R4939 VDD.n2070 VDD.n2066 0.402
R4940 VDD.n2070 VDD.n2069 0.402
R4941 VDD.n2069 VDD.n11 0.402
R4942 VDD.n1520 VDD.t64 0.389346
R4943 VDD.n1567 VDD.t26 0.389346
R4944 VDD.n1521 VDD.t65 0.388966
R4945 VDD.n1522 VDD.t67 0.388966
R4946 VDD.n1547 VDD.t35 0.388966
R4947 VDD.n1546 VDD.t37 0.388966
R4948 VDD.n1542 VDD.t69 0.388788
R4949 VDD.n1575 VDD.t39 0.388788
R4950 VDD.n599 VDD.n598 0.381681
R4951 VDD.n600 VDD.n597 0.381681
R4952 VDD.n372 VDD.n370 0.381681
R4953 VDD.n365 VDD.n364 0.381681
R4954 VDD.n1517 VDD.t52 0.379724
R4955 VDD.n1548 VDD.t14 0.379724
R4956 VDD.n1516 VDD.t46 0.37972
R4957 VDD.n1519 VDD.t58 0.37972
R4958 VDD.n1556 VDD.t8 0.37972
R4959 VDD.n1566 VDD.t20 0.37972
R4960 VDD.n1529 VDD.t53 0.379497
R4961 VDD.n1536 VDD.t55 0.379497
R4962 VDD.n1523 VDD.t57 0.379497
R4963 VDD.n1561 VDD.t15 0.379497
R4964 VDD.n1552 VDD.t17 0.379497
R4965 VDD.n1572 VDD.t19 0.379497
R4966 VDD.n1530 VDD.t47 0.379494
R4967 VDD.n1527 VDD.t59 0.379494
R4968 VDD.n1535 VDD.t49 0.379494
R4969 VDD.n1537 VDD.t61 0.379494
R4970 VDD.n1541 VDD.t63 0.379494
R4971 VDD.n1525 VDD.t51 0.379494
R4972 VDD.n1560 VDD.t9 0.379494
R4973 VDD.n1562 VDD.t21 0.379494
R4974 VDD.n1553 VDD.t11 0.379494
R4975 VDD.n1550 VDD.t23 0.379494
R4976 VDD.n1574 VDD.t25 0.379494
R4977 VDD.n1571 VDD.t13 0.379494
R4978 VDD.n606 VDD.t642 0.370065
R4979 VDD.n373 VDD.t633 0.370065
R4980 VDD.n605 VDD.n603 0.360757
R4981 VDD.n367 VDD.n366 0.360757
R4982 VDD.n200 VDD.n193 0.312107
R4983 VDD.n207 VDD.n200 0.312107
R4984 VDD.n214 VDD.n178 0.312107
R4985 VDD.n232 VDD.n225 0.312107
R4986 VDD.n247 VDD.n240 0.312107
R4987 VDD.n254 VDD.n163 0.312107
R4988 VDD.n259 VDD.n163 0.312107
R4989 VDD.n266 VDD.n259 0.312107
R4990 VDD.n273 VDD.n266 0.312107
R4991 VDD.n288 VDD.n281 0.312107
R4992 VDD.n295 VDD.n155 0.312107
R4993 VDD.n314 VDD.n307 0.312107
R4994 VDD.n329 VDD.n322 0.312107
R4995 VDD.n336 VDD.n329 0.312107
R4996 VDD.n215 VDD.n214 0.306336
R4997 VDD.n315 VDD.n314 0.306336
R4998 VDD.n806 VDD.n609 0.304502
R4999 VDD.n809 VDD.n609 0.304502
R5000 VDD.n582 VDD.n376 0.304502
R5001 VDD.n579 VDD.n376 0.304502
R5002 VDD.n803 VDD.n796 0.299584
R5003 VDD.n804 VDD.n803 0.299584
R5004 VDD.n585 VDD.n383 0.299584
R5005 VDD.n2231 VDD.n2230 0.279228
R5006 VDD.n595 VDD.n594 0.2755
R5007 VDD.n828 VDD.n827 0.2755
R5008 VDD.n820 VDD.n618 0.27491
R5009 VDD.n819 VDD.n619 0.27491
R5010 VDD.n818 VDD.n620 0.27491
R5011 VDD.n566 VDD.n447 0.27491
R5012 VDD.n565 VDD.n504 0.27491
R5013 VDD.n564 VDD.n561 0.27491
R5014 VDD.n608 VDD.n596 0.255237
R5015 VDD.n375 VDD.n374 0.255237
R5016 VDD.n1921 VDD.n24 0.247168
R5017 VDD.n607 VDD.n597 0.242734
R5018 VDD.n370 VDD.n363 0.242734
R5019 VDD.n816 VDD.n815 0.24067
R5020 VDD.n803 VDD.n802 0.24067
R5021 VDD.n586 VDD.n585 0.24067
R5022 VDD.n570 VDD.n568 0.24067
R5023 VDD.n255 VDD.n247 0.235648
R5024 VDD.n281 VDD.n274 0.235648
R5025 VDD.n1132 VDD.n1131 0.230924
R5026 VDD.n2220 VDD.n2219 0.230924
R5027 VDD.n833 VDD.t622 0.23023
R5028 VDD.n225 VDD.n218 0.229877
R5029 VDD.n300 VDD.n155 0.229877
R5030 VDD.n1923 VDD.n24 0.215825
R5031 VDD.n571 VDD.n570 0.214017
R5032 VDD.n608 VDD.n607 0.213786
R5033 VDD.n375 VDD.n363 0.213786
R5034 VDD.n815 VDD.n814 0.212026
R5035 VDD.n595 VDD.n376 0.207433
R5036 VDD.n828 VDD.n609 0.207433
R5037 VDD.n1578 VDD.n1577 0.199591
R5038 VDD.n258 VDD.n257 0.170008
R5039 VDD.n815 VDD.n621 0.163443
R5040 VDD.n679 VDD.n678 0.163443
R5041 VDD.n737 VDD.n736 0.163443
R5042 VDD.n795 VDD.n794 0.163443
R5043 VDD.n386 VDD.n385 0.163443
R5044 VDD.n388 VDD.n387 0.163443
R5045 VDD.n390 VDD.n389 0.163443
R5046 VDD.n570 VDD.n569 0.163443
R5047 VDD.n233 VDD.n232 0.159189
R5048 VDD.n296 VDD.n295 0.159189
R5049 VDD.n1148 VDD.n1147 0.15901
R5050 VDD.n2236 VDD.n2235 0.15901
R5051 VDD.n801 VDD.n617 0.157333
R5052 VDD.n588 VDD.n587 0.157333
R5053 VDD.n240 VDD.n233 0.153418
R5054 VDD.n296 VDD.n288 0.153418
R5055 VDD.n1923 VDD.n15 0.149787
R5056 VDD.n812 VDD.n795 0.147515
R5057 VDD.n813 VDD.n737 0.147515
R5058 VDD.n814 VDD.n679 0.147515
R5059 VDD.n571 VDD.n390 0.147515
R5060 VDD.n572 VDD.n388 0.147515
R5061 VDD.n573 VDD.n386 0.147515
R5062 VDD.n1580 VDD.n1579 0.146158
R5063 VDD.n1625 VDD.n1580 0.140878
R5064 VDD.n820 VDD.n819 0.13733
R5065 VDD.n819 VDD.n818 0.13733
R5066 VDD.n566 VDD.n565 0.13733
R5067 VDD.n565 VDD.n564 0.13733
R5068 VDD.n843 VDD.n842 0.121348
R5069 VDD.n821 VDD.n820 0.120915
R5070 VDD.n564 VDD.n563 0.120915
R5071 VDD VDD.n0 0.114413
R5072 VDD.n1136 VDD.n860 0.10775
R5073 VDD.n1137 VDD.n859 0.10775
R5074 VDD.n1138 VDD.n858 0.10775
R5075 VDD.n1139 VDD.n857 0.10775
R5076 VDD.n1140 VDD.n856 0.10775
R5077 VDD.n1141 VDD.n855 0.10775
R5078 VDD.n1142 VDD.n854 0.10775
R5079 VDD.n1135 VDD.n861 0.10775
R5080 VDD.n1145 VDD.n853 0.10775
R5081 VDD.n1132 VDD.n862 0.10775
R5082 VDD.n1146 VDD.n852 0.10775
R5083 VDD.n1147 VDD.n851 0.10775
R5084 VDD.n2144 VDD.n14 0.10775
R5085 VDD.n2163 VDD.n2162 0.10775
R5086 VDD.n2164 VDD.n1958 0.10775
R5087 VDD.n2165 VDD.n1957 0.10775
R5088 VDD.n2166 VDD.n1956 0.10775
R5089 VDD.n2167 VDD.n1955 0.10775
R5090 VDD.n2169 VDD.n2168 0.10775
R5091 VDD.n2233 VDD.n13 0.10775
R5092 VDD.n2178 VDD.n1935 0.10775
R5093 VDD.n2234 VDD.n12 0.10775
R5094 VDD.n2220 VDD.n1936 0.10775
R5095 VDD.n2235 VDD.n11 0.10775
R5096 VDD.n1579 VDD.n24 0.107583
R5097 VDD.n1923 VDD.n26 0.103238
R5098 VDD.n1578 VDD.n1513 0.0985571
R5099 VDD.n1577 VDD.n1545 0.0985571
R5100 VDD.n1578 VDD.n1514 0.0985571
R5101 VDD.n1577 VDD.n1576 0.0985571
R5102 VDD.n1580 VDD.n1511 0.0985571
R5103 VDD.n1580 VDD.n1512 0.0985571
R5104 VDD.n839 VDD.n838 0.0949633
R5105 VDD.n598 VDD.n596 0.0873421
R5106 VDD.n374 VDD.n364 0.0873421
R5107 VDD.n218 VDD.n178 0.0827295
R5108 VDD.n307 VDD.n300 0.0827295
R5109 VDD.t1 VDD.n21 0.0809066
R5110 VDD.n255 VDD.n254 0.076959
R5111 VDD.n274 VDD.n273 0.076959
R5112 VDD.n193 VDD.n186 0.0711885
R5113 VDD.n343 VDD.n336 0.0711885
R5114 VDD.n1147 VDD.n1146 0.07002
R5115 VDD.n1146 VDD.n1145 0.07002
R5116 VDD.n1142 VDD.n1141 0.07002
R5117 VDD.n1141 VDD.n1140 0.07002
R5118 VDD.n1140 VDD.n1139 0.07002
R5119 VDD.n1139 VDD.n1138 0.07002
R5120 VDD.n1138 VDD.n1137 0.07002
R5121 VDD.n1137 VDD.n1136 0.07002
R5122 VDD.n1136 VDD.n1135 0.07002
R5123 VDD.n2235 VDD.n2234 0.07002
R5124 VDD.n2234 VDD.n2233 0.07002
R5125 VDD.n2163 VDD.n14 0.07002
R5126 VDD.n2164 VDD.n2163 0.07002
R5127 VDD.n2165 VDD.n2164 0.07002
R5128 VDD.n2166 VDD.n2165 0.07002
R5129 VDD.n2167 VDD.n2166 0.07002
R5130 VDD.n2168 VDD.n2167 0.07002
R5131 VDD.n2168 VDD.n1935 0.07002
R5132 VDD.n836 VDD.n830 0.0676186
R5133 VDD.n813 VDD.n812 0.067002
R5134 VDD.n814 VDD.n813 0.067002
R5135 VDD.n572 VDD.n571 0.067002
R5136 VDD.n573 VDD.n572 0.067002
R5137 VDD.n1923 VDD.n27 0.0651324
R5138 VDD.n812 VDD.n811 0.0584195
R5139 VDD.n584 VDD.n573 0.0584195
R5140 VDD.n1579 VDD.n1578 0.057876
R5141 VDD.n1144 VDD.n1142 0.05781
R5142 VDD.n2232 VDD.n14 0.05781
R5143 VDD.n362 VDD.n135 0.0537317
R5144 VDD.n358 VDD.n135 0.0537317
R5145 VDD.n358 VDD.n357 0.0537317
R5146 VDD.n357 VDD.n356 0.0537317
R5147 VDD.n356 VDD.n140 0.0537317
R5148 VDD.n352 VDD.n140 0.0537317
R5149 VDD.n352 VDD.n351 0.0537317
R5150 VDD.n351 VDD.n350 0.0537317
R5151 VDD.n350 VDD.n145 0.0537317
R5152 VDD.n346 VDD.n145 0.0537317
R5153 VDD.n1134 VDD.n1132 0.04373
R5154 VDD.n2221 VDD.n2220 0.04373
R5155 VDD.n1923 VDD.n22 0.0372523
R5156 VDD.n1923 VDD.n25 0.0372523
R5157 VDD.n1171 VDD.n127 0.0331154
R5158 VDD.n1200 VDD.n113 0.0331154
R5159 VDD.n104 VDD.n103 0.0331154
R5160 VDD.n1256 VDD.n83 0.0331154
R5161 VDD.n1281 VDD.n67 0.0331154
R5162 VDD.n1308 VDD.n53 0.0331154
R5163 VDD.n46 VDD.n45 0.0331154
R5164 VDD.n1601 VDD.n1586 0.0331154
R5165 VDD.n1357 VDD.n1356 0.0331154
R5166 VDD.n1633 VDD.n1492 0.0331154
R5167 VDD.n1387 VDD.n1386 0.0331154
R5168 VDD.n1667 VDD.n1399 0.0331154
R5169 VDD.n1685 VDD.n1480 0.0331154
R5170 VDD.n1417 VDD.n1416 0.0331154
R5171 VDD.n1717 VDD.n1429 0.0331154
R5172 VDD.n1735 VDD.n1468 0.0331154
R5173 VDD.n1446 VDD.n1445 0.0331154
R5174 VDD.n1769 VDD.n1458 0.0331154
R5175 VDD.n1172 VDD.n128 0.0331154
R5176 VDD.n1199 VDD.n112 0.0331154
R5177 VDD.n1231 VDD.n1230 0.0331154
R5178 VDD.n1255 VDD.n82 0.0331154
R5179 VDD.n1282 VDD.n68 0.0331154
R5180 VDD.n1307 VDD.n52 0.0331154
R5181 VDD.n1337 VDD.n1336 0.0331154
R5182 VDD.n1600 VDD.n1585 0.0331154
R5183 VDD.n1903 VDD.n1902 0.0331154
R5184 VDD.n1632 VDD.n1491 0.0331154
R5185 VDD.n1869 VDD.n1868 0.0331154
R5186 VDD.n1855 VDD.n1400 0.0331154
R5187 VDD.n1684 VDD.n1479 0.0331154
R5188 VDD.n1835 VDD.n1834 0.0331154
R5189 VDD.n1821 VDD.n1430 0.0331154
R5190 VDD.n1734 VDD.n1467 0.0331154
R5191 VDD.n1801 VDD.n1800 0.0331154
R5192 VDD.n1787 VDD.n1459 0.0331154
R5193 VDD.n1174 VDD.n1173 0.0331154
R5194 VDD.n1198 VDD.n111 0.0331154
R5195 VDD.n1232 VDD.n102 0.0331154
R5196 VDD.n1254 VDD.n81 0.0331154
R5197 VDD.n1284 VDD.n1283 0.0331154
R5198 VDD.n1306 VDD.n51 0.0331154
R5199 VDD.n1338 VDD.n44 0.0331154
R5200 VDD.n1599 VDD.n1584 0.0331154
R5201 VDD.n1904 VDD.n1355 0.0331154
R5202 VDD.n1631 VDD.n1490 0.0331154
R5203 VDD.n1870 VDD.n1385 0.0331154
R5204 VDD.n1854 VDD.n1853 0.0331154
R5205 VDD.n1683 VDD.n1478 0.0331154
R5206 VDD.n1836 VDD.n1415 0.0331154
R5207 VDD.n1820 VDD.n1819 0.0331154
R5208 VDD.n1733 VDD.n1466 0.0331154
R5209 VDD.n1802 VDD.n1444 0.0331154
R5210 VDD.n1786 VDD.n1785 0.0331154
R5211 VDD.n672 VDD.n620 0.0330814
R5212 VDD.n730 VDD.n619 0.0330814
R5213 VDD.n788 VDD.n618 0.0330814
R5214 VDD.n561 VDD.n505 0.0330814
R5215 VDD.n504 VDD.n448 0.0330814
R5216 VDD.n447 VDD.n391 0.0330814
R5217 VDD.n674 VDD.n673 0.0317931
R5218 VDD.n732 VDD.n731 0.0317931
R5219 VDD.n790 VDD.n789 0.0317931
R5220 VDD.n559 VDD.n558 0.0317931
R5221 VDD.n502 VDD.n501 0.0317931
R5222 VDD.n445 VDD.n444 0.0317931
R5223 VDD.n1150 VDD.n850 0.0300385
R5224 VDD.n1150 VDD.n848 0.0300385
R5225 VDD.n1157 VDD.n848 0.0300385
R5226 VDD.n1157 VDD.n846 0.0300385
R5227 VDD.n1161 VDD.n846 0.0300385
R5228 VDD.n1161 VDD.n133 0.0300385
R5229 VDD.n1167 VDD.n133 0.0300385
R5230 VDD.n1167 VDD.n131 0.0300385
R5231 VDD.n1171 VDD.n131 0.0300385
R5232 VDD.n1177 VDD.n127 0.0300385
R5233 VDD.n1177 VDD.n125 0.0300385
R5234 VDD.n1181 VDD.n125 0.0300385
R5235 VDD.n1181 VDD.n121 0.0300385
R5236 VDD.n1188 VDD.n121 0.0300385
R5237 VDD.n1188 VDD.n119 0.0300385
R5238 VDD.n1194 VDD.n119 0.0300385
R5239 VDD.n1194 VDD.n115 0.0300385
R5240 VDD.n1200 VDD.n115 0.0300385
R5241 VDD.n1205 VDD.n113 0.0300385
R5242 VDD.n1205 VDD.n109 0.0300385
R5243 VDD.n1211 VDD.n109 0.0300385
R5244 VDD.n1212 VDD.n1211 0.0300385
R5245 VDD.n1212 VDD.n98 0.0300385
R5246 VDD.n99 VDD.n98 0.0300385
R5247 VDD.n100 VDD.n99 0.0300385
R5248 VDD.n1217 VDD.n100 0.0300385
R5249 VDD.n1217 VDD.n103 0.0300385
R5250 VDD.n105 VDD.n104 0.0300385
R5251 VDD.n107 VDD.n105 0.0300385
R5252 VDD.n1224 VDD.n107 0.0300385
R5253 VDD.n1224 VDD.n91 0.0300385
R5254 VDD.n1246 VDD.n91 0.0300385
R5255 VDD.n1246 VDD.n89 0.0300385
R5256 VDD.n1250 VDD.n89 0.0300385
R5257 VDD.n1250 VDD.n85 0.0300385
R5258 VDD.n1256 VDD.n85 0.0300385
R5259 VDD.n1260 VDD.n83 0.0300385
R5260 VDD.n1260 VDD.n79 0.0300385
R5261 VDD.n1267 VDD.n79 0.0300385
R5262 VDD.n1267 VDD.n77 0.0300385
R5263 VDD.n1271 VDD.n77 0.0300385
R5264 VDD.n1271 VDD.n73 0.0300385
R5265 VDD.n1277 VDD.n73 0.0300385
R5266 VDD.n1277 VDD.n71 0.0300385
R5267 VDD.n1281 VDD.n71 0.0300385
R5268 VDD.n1287 VDD.n67 0.0300385
R5269 VDD.n1287 VDD.n65 0.0300385
R5270 VDD.n1291 VDD.n65 0.0300385
R5271 VDD.n1291 VDD.n61 0.0300385
R5272 VDD.n1298 VDD.n61 0.0300385
R5273 VDD.n1298 VDD.n59 0.0300385
R5274 VDD.n1302 VDD.n59 0.0300385
R5275 VDD.n1302 VDD.n55 0.0300385
R5276 VDD.n1308 VDD.n55 0.0300385
R5277 VDD.n1313 VDD.n53 0.0300385
R5278 VDD.n1313 VDD.n49 0.0300385
R5279 VDD.n1319 VDD.n49 0.0300385
R5280 VDD.n1320 VDD.n1319 0.0300385
R5281 VDD.n1320 VDD.n40 0.0300385
R5282 VDD.n41 VDD.n40 0.0300385
R5283 VDD.n42 VDD.n41 0.0300385
R5284 VDD.n1325 VDD.n42 0.0300385
R5285 VDD.n1325 VDD.n45 0.0300385
R5286 VDD.n47 VDD.n46 0.0300385
R5287 VDD.n1331 VDD.n47 0.0300385
R5288 VDD.n1331 VDD.n30 0.0300385
R5289 VDD.n1917 VDD.n30 0.0300385
R5290 VDD.n1917 VDD.n31 0.0300385
R5291 VDD.n1592 VDD.n31 0.0300385
R5292 VDD.n1595 VDD.n1592 0.0300385
R5293 VDD.n1595 VDD.n1588 0.0300385
R5294 VDD.n1601 VDD.n1588 0.0300385
R5295 VDD.n1606 VDD.n1586 0.0300385
R5296 VDD.n1606 VDD.n1582 0.0300385
R5297 VDD.n1612 VDD.n1582 0.0300385
R5298 VDD.n1613 VDD.n1612 0.0300385
R5299 VDD.n1613 VDD.n1351 0.0300385
R5300 VDD.n1352 VDD.n1351 0.0300385
R5301 VDD.n1353 VDD.n1352 0.0300385
R5302 VDD.n1618 VDD.n1353 0.0300385
R5303 VDD.n1618 VDD.n1356 0.0300385
R5304 VDD.n1358 VDD.n1357 0.0300385
R5305 VDD.n1623 VDD.n1358 0.0300385
R5306 VDD.n1623 VDD.n1361 0.0300385
R5307 VDD.n1362 VDD.n1361 0.0300385
R5308 VDD.n1500 VDD.n1363 0.0300385
R5309 VDD.n1368 VDD.n1367 0.0300385
R5310 VDD.n1503 VDD.n1369 0.0300385
R5311 VDD.n1373 VDD.n1372 0.0300385
R5312 VDD.n1506 VDD.n1374 0.0300385
R5313 VDD.n1508 VDD.n1498 0.0300385
R5314 VDD.n1627 VDD.n1498 0.0300385
R5315 VDD.n1627 VDD.n1494 0.0300385
R5316 VDD.n1633 VDD.n1494 0.0300385
R5317 VDD.n1638 VDD.n1492 0.0300385
R5318 VDD.n1638 VDD.n1488 0.0300385
R5319 VDD.n1644 VDD.n1488 0.0300385
R5320 VDD.n1645 VDD.n1644 0.0300385
R5321 VDD.n1645 VDD.n1381 0.0300385
R5322 VDD.n1382 VDD.n1381 0.0300385
R5323 VDD.n1383 VDD.n1382 0.0300385
R5324 VDD.n1650 VDD.n1383 0.0300385
R5325 VDD.n1650 VDD.n1386 0.0300385
R5326 VDD.n1388 VDD.n1387 0.0300385
R5327 VDD.n1655 VDD.n1388 0.0300385
R5328 VDD.n1655 VDD.n1391 0.0300385
R5329 VDD.n1392 VDD.n1391 0.0300385
R5330 VDD.n1393 VDD.n1392 0.0300385
R5331 VDD.n1662 VDD.n1393 0.0300385
R5332 VDD.n1662 VDD.n1397 0.0300385
R5333 VDD.n1398 VDD.n1397 0.0300385
R5334 VDD.n1399 VDD.n1398 0.0300385
R5335 VDD.n1667 VDD.n1402 0.0300385
R5336 VDD.n1403 VDD.n1402 0.0300385
R5337 VDD.n1404 VDD.n1403 0.0300385
R5338 VDD.n1673 VDD.n1404 0.0300385
R5339 VDD.n1675 VDD.n1673 0.0300385
R5340 VDD.n1675 VDD.n1486 0.0300385
R5341 VDD.n1679 VDD.n1486 0.0300385
R5342 VDD.n1679 VDD.n1482 0.0300385
R5343 VDD.n1685 VDD.n1482 0.0300385
R5344 VDD.n1690 VDD.n1480 0.0300385
R5345 VDD.n1690 VDD.n1476 0.0300385
R5346 VDD.n1696 VDD.n1476 0.0300385
R5347 VDD.n1697 VDD.n1696 0.0300385
R5348 VDD.n1697 VDD.n1411 0.0300385
R5349 VDD.n1412 VDD.n1411 0.0300385
R5350 VDD.n1413 VDD.n1412 0.0300385
R5351 VDD.n1702 VDD.n1413 0.0300385
R5352 VDD.n1702 VDD.n1416 0.0300385
R5353 VDD.n1418 VDD.n1417 0.0300385
R5354 VDD.n1707 VDD.n1418 0.0300385
R5355 VDD.n1707 VDD.n1421 0.0300385
R5356 VDD.n1422 VDD.n1421 0.0300385
R5357 VDD.n1423 VDD.n1422 0.0300385
R5358 VDD.n1712 VDD.n1423 0.0300385
R5359 VDD.n1712 VDD.n1427 0.0300385
R5360 VDD.n1428 VDD.n1427 0.0300385
R5361 VDD.n1429 VDD.n1428 0.0300385
R5362 VDD.n1717 VDD.n1432 0.0300385
R5363 VDD.n1433 VDD.n1432 0.0300385
R5364 VDD.n1434 VDD.n1433 0.0300385
R5365 VDD.n1723 VDD.n1434 0.0300385
R5366 VDD.n1725 VDD.n1723 0.0300385
R5367 VDD.n1725 VDD.n1474 0.0300385
R5368 VDD.n1729 VDD.n1474 0.0300385
R5369 VDD.n1729 VDD.n1470 0.0300385
R5370 VDD.n1735 VDD.n1470 0.0300385
R5371 VDD.n1740 VDD.n1468 0.0300385
R5372 VDD.n1740 VDD.n1464 0.0300385
R5373 VDD.n1746 VDD.n1464 0.0300385
R5374 VDD.n1747 VDD.n1746 0.0300385
R5375 VDD.n1747 VDD.n1440 0.0300385
R5376 VDD.n1441 VDD.n1440 0.0300385
R5377 VDD.n1442 VDD.n1441 0.0300385
R5378 VDD.n1752 VDD.n1442 0.0300385
R5379 VDD.n1752 VDD.n1445 0.0300385
R5380 VDD.n1447 VDD.n1446 0.0300385
R5381 VDD.n1757 VDD.n1447 0.0300385
R5382 VDD.n1757 VDD.n1450 0.0300385
R5383 VDD.n1451 VDD.n1450 0.0300385
R5384 VDD.n1452 VDD.n1451 0.0300385
R5385 VDD.n1764 VDD.n1452 0.0300385
R5386 VDD.n1764 VDD.n1456 0.0300385
R5387 VDD.n1457 VDD.n1456 0.0300385
R5388 VDD.n1458 VDD.n1457 0.0300385
R5389 VDD.n1769 VDD.n1461 0.0300385
R5390 VDD.n1462 VDD.n1461 0.0300385
R5391 VDD.n1779 VDD.n1462 0.0300385
R5392 VDD.n1779 VDD.n1778 0.0300385
R5393 VDD.n1778 VDD.n5 0.0300385
R5394 VDD.n6 VDD.n5 0.0300385
R5395 VDD.n7 VDD.n6 0.0300385
R5396 VDD.n9 VDD.n7 0.0300385
R5397 VDD.n2237 VDD.n9 0.0300385
R5398 VDD.n1151 VDD.n849 0.0300385
R5399 VDD.n1156 VDD.n849 0.0300385
R5400 VDD.n1156 VDD.n845 0.0300385
R5401 VDD.n1162 VDD.n845 0.0300385
R5402 VDD.n1162 VDD.n134 0.0300385
R5403 VDD.n1166 VDD.n134 0.0300385
R5404 VDD.n1166 VDD.n130 0.0300385
R5405 VDD.n1172 VDD.n130 0.0300385
R5406 VDD.n1176 VDD.n128 0.0300385
R5407 VDD.n1176 VDD.n124 0.0300385
R5408 VDD.n1182 VDD.n124 0.0300385
R5409 VDD.n1182 VDD.n122 0.0300385
R5410 VDD.n1187 VDD.n122 0.0300385
R5411 VDD.n1187 VDD.n118 0.0300385
R5412 VDD.n1195 VDD.n118 0.0300385
R5413 VDD.n1195 VDD.n116 0.0300385
R5414 VDD.n1199 VDD.n116 0.0300385
R5415 VDD.n1206 VDD.n112 0.0300385
R5416 VDD.n1206 VDD.n110 0.0300385
R5417 VDD.n1210 VDD.n110 0.0300385
R5418 VDD.n1210 VDD.n97 0.0300385
R5419 VDD.n1237 VDD.n97 0.0300385
R5420 VDD.n1237 VDD.n1236 0.0300385
R5421 VDD.n1236 VDD.n1235 0.0300385
R5422 VDD.n1235 VDD.n101 0.0300385
R5423 VDD.n1231 VDD.n101 0.0300385
R5424 VDD.n1230 VDD.n1229 0.0300385
R5425 VDD.n1229 VDD.n106 0.0300385
R5426 VDD.n1225 VDD.n106 0.0300385
R5427 VDD.n1225 VDD.n92 0.0300385
R5428 VDD.n1245 VDD.n92 0.0300385
R5429 VDD.n1245 VDD.n88 0.0300385
R5430 VDD.n1251 VDD.n88 0.0300385
R5431 VDD.n1251 VDD.n86 0.0300385
R5432 VDD.n1255 VDD.n86 0.0300385
R5433 VDD.n1261 VDD.n82 0.0300385
R5434 VDD.n1261 VDD.n80 0.0300385
R5435 VDD.n1266 VDD.n80 0.0300385
R5436 VDD.n1266 VDD.n76 0.0300385
R5437 VDD.n1272 VDD.n76 0.0300385
R5438 VDD.n1272 VDD.n74 0.0300385
R5439 VDD.n1276 VDD.n74 0.0300385
R5440 VDD.n1276 VDD.n70 0.0300385
R5441 VDD.n1282 VDD.n70 0.0300385
R5442 VDD.n1286 VDD.n68 0.0300385
R5443 VDD.n1286 VDD.n64 0.0300385
R5444 VDD.n1292 VDD.n64 0.0300385
R5445 VDD.n1292 VDD.n62 0.0300385
R5446 VDD.n1297 VDD.n62 0.0300385
R5447 VDD.n1297 VDD.n58 0.0300385
R5448 VDD.n1303 VDD.n58 0.0300385
R5449 VDD.n1303 VDD.n56 0.0300385
R5450 VDD.n1307 VDD.n56 0.0300385
R5451 VDD.n1314 VDD.n52 0.0300385
R5452 VDD.n1314 VDD.n50 0.0300385
R5453 VDD.n1318 VDD.n50 0.0300385
R5454 VDD.n1318 VDD.n39 0.0300385
R5455 VDD.n1343 VDD.n39 0.0300385
R5456 VDD.n1343 VDD.n1342 0.0300385
R5457 VDD.n1342 VDD.n1341 0.0300385
R5458 VDD.n1341 VDD.n43 0.0300385
R5459 VDD.n1337 VDD.n43 0.0300385
R5460 VDD.n1336 VDD.n1335 0.0300385
R5461 VDD.n1335 VDD.n1332 0.0300385
R5462 VDD.n1332 VDD.n32 0.0300385
R5463 VDD.n1916 VDD.n32 0.0300385
R5464 VDD.n1916 VDD.n33 0.0300385
R5465 VDD.n1591 VDD.n33 0.0300385
R5466 VDD.n1596 VDD.n1591 0.0300385
R5467 VDD.n1596 VDD.n1589 0.0300385
R5468 VDD.n1600 VDD.n1589 0.0300385
R5469 VDD.n1607 VDD.n1585 0.0300385
R5470 VDD.n1607 VDD.n1583 0.0300385
R5471 VDD.n1611 VDD.n1583 0.0300385
R5472 VDD.n1611 VDD.n1350 0.0300385
R5473 VDD.n1909 VDD.n1350 0.0300385
R5474 VDD.n1909 VDD.n1908 0.0300385
R5475 VDD.n1908 VDD.n1907 0.0300385
R5476 VDD.n1907 VDD.n1354 0.0300385
R5477 VDD.n1903 VDD.n1354 0.0300385
R5478 VDD.n1902 VDD.n1901 0.0300385
R5479 VDD.n1901 VDD.n1359 0.0300385
R5480 VDD.n1897 VDD.n1359 0.0300385
R5481 VDD.n1897 VDD.n1896 0.0300385
R5482 VDD.n1896 VDD.n1895 0.0300385
R5483 VDD.n1895 VDD.n1364 0.0300385
R5484 VDD.n1891 VDD.n1364 0.0300385
R5485 VDD.n1891 VDD.n1890 0.0300385
R5486 VDD.n1890 VDD.n1889 0.0300385
R5487 VDD.n1889 VDD.n1370 0.0300385
R5488 VDD.n1885 VDD.n1370 0.0300385
R5489 VDD.n1885 VDD.n1884 0.0300385
R5490 VDD.n1884 VDD.n1883 0.0300385
R5491 VDD.n1883 VDD.n1375 0.0300385
R5492 VDD.n1507 VDD.n1375 0.0300385
R5493 VDD.n1507 VDD.n1497 0.0300385
R5494 VDD.n1628 VDD.n1497 0.0300385
R5495 VDD.n1628 VDD.n1495 0.0300385
R5496 VDD.n1632 VDD.n1495 0.0300385
R5497 VDD.n1639 VDD.n1491 0.0300385
R5498 VDD.n1639 VDD.n1489 0.0300385
R5499 VDD.n1643 VDD.n1489 0.0300385
R5500 VDD.n1643 VDD.n1380 0.0300385
R5501 VDD.n1875 VDD.n1380 0.0300385
R5502 VDD.n1875 VDD.n1874 0.0300385
R5503 VDD.n1874 VDD.n1873 0.0300385
R5504 VDD.n1873 VDD.n1384 0.0300385
R5505 VDD.n1869 VDD.n1384 0.0300385
R5506 VDD.n1868 VDD.n1867 0.0300385
R5507 VDD.n1867 VDD.n1389 0.0300385
R5508 VDD.n1863 VDD.n1389 0.0300385
R5509 VDD.n1863 VDD.n1862 0.0300385
R5510 VDD.n1862 VDD.n1861 0.0300385
R5511 VDD.n1861 VDD.n1394 0.0300385
R5512 VDD.n1857 VDD.n1394 0.0300385
R5513 VDD.n1857 VDD.n1856 0.0300385
R5514 VDD.n1856 VDD.n1855 0.0300385
R5515 VDD.n1851 VDD.n1400 0.0300385
R5516 VDD.n1851 VDD.n1850 0.0300385
R5517 VDD.n1850 VDD.n1849 0.0300385
R5518 VDD.n1849 VDD.n1405 0.0300385
R5519 VDD.n1674 VDD.n1405 0.0300385
R5520 VDD.n1674 VDD.n1485 0.0300385
R5521 VDD.n1680 VDD.n1485 0.0300385
R5522 VDD.n1680 VDD.n1483 0.0300385
R5523 VDD.n1684 VDD.n1483 0.0300385
R5524 VDD.n1691 VDD.n1479 0.0300385
R5525 VDD.n1691 VDD.n1477 0.0300385
R5526 VDD.n1695 VDD.n1477 0.0300385
R5527 VDD.n1695 VDD.n1410 0.0300385
R5528 VDD.n1841 VDD.n1410 0.0300385
R5529 VDD.n1841 VDD.n1840 0.0300385
R5530 VDD.n1840 VDD.n1839 0.0300385
R5531 VDD.n1839 VDD.n1414 0.0300385
R5532 VDD.n1835 VDD.n1414 0.0300385
R5533 VDD.n1834 VDD.n1833 0.0300385
R5534 VDD.n1833 VDD.n1419 0.0300385
R5535 VDD.n1829 VDD.n1419 0.0300385
R5536 VDD.n1829 VDD.n1828 0.0300385
R5537 VDD.n1828 VDD.n1827 0.0300385
R5538 VDD.n1827 VDD.n1424 0.0300385
R5539 VDD.n1823 VDD.n1424 0.0300385
R5540 VDD.n1823 VDD.n1822 0.0300385
R5541 VDD.n1822 VDD.n1821 0.0300385
R5542 VDD.n1817 VDD.n1430 0.0300385
R5543 VDD.n1817 VDD.n1816 0.0300385
R5544 VDD.n1816 VDD.n1815 0.0300385
R5545 VDD.n1815 VDD.n1435 0.0300385
R5546 VDD.n1724 VDD.n1435 0.0300385
R5547 VDD.n1724 VDD.n1473 0.0300385
R5548 VDD.n1730 VDD.n1473 0.0300385
R5549 VDD.n1730 VDD.n1471 0.0300385
R5550 VDD.n1734 VDD.n1471 0.0300385
R5551 VDD.n1741 VDD.n1467 0.0300385
R5552 VDD.n1741 VDD.n1465 0.0300385
R5553 VDD.n1745 VDD.n1465 0.0300385
R5554 VDD.n1745 VDD.n1439 0.0300385
R5555 VDD.n1807 VDD.n1439 0.0300385
R5556 VDD.n1807 VDD.n1806 0.0300385
R5557 VDD.n1806 VDD.n1805 0.0300385
R5558 VDD.n1805 VDD.n1443 0.0300385
R5559 VDD.n1801 VDD.n1443 0.0300385
R5560 VDD.n1800 VDD.n1799 0.0300385
R5561 VDD.n1799 VDD.n1448 0.0300385
R5562 VDD.n1795 VDD.n1448 0.0300385
R5563 VDD.n1795 VDD.n1794 0.0300385
R5564 VDD.n1794 VDD.n1793 0.0300385
R5565 VDD.n1793 VDD.n1453 0.0300385
R5566 VDD.n1789 VDD.n1453 0.0300385
R5567 VDD.n1789 VDD.n1788 0.0300385
R5568 VDD.n1788 VDD.n1787 0.0300385
R5569 VDD.n1783 VDD.n1459 0.0300385
R5570 VDD.n1783 VDD.n1782 0.0300385
R5571 VDD.n1782 VDD.n1781 0.0300385
R5572 VDD.n1781 VDD.n4 0.0300385
R5573 VDD.n2242 VDD.n4 0.0300385
R5574 VDD.n2242 VDD.n2241 0.0300385
R5575 VDD.n2241 VDD.n2240 0.0300385
R5576 VDD.n2240 VDD.n8 0.0300385
R5577 VDD.n1155 VDD.n1153 0.0300385
R5578 VDD.n1155 VDD.n1154 0.0300385
R5579 VDD.n1164 VDD.n1163 0.0300385
R5580 VDD.n1165 VDD.n1164 0.0300385
R5581 VDD.n1165 VDD.n129 0.0300385
R5582 VDD.n1173 VDD.n129 0.0300385
R5583 VDD.n1175 VDD.n1174 0.0300385
R5584 VDD.n1175 VDD.n123 0.0300385
R5585 VDD.n1183 VDD.n123 0.0300385
R5586 VDD.n1184 VDD.n1183 0.0300385
R5587 VDD.n1186 VDD.n117 0.0300385
R5588 VDD.n1196 VDD.n117 0.0300385
R5589 VDD.n1197 VDD.n1196 0.0300385
R5590 VDD.n1198 VDD.n1197 0.0300385
R5591 VDD.n1207 VDD.n111 0.0300385
R5592 VDD.n1208 VDD.n1207 0.0300385
R5593 VDD.n1209 VDD.n1208 0.0300385
R5594 VDD.n1209 VDD.n95 0.0300385
R5595 VDD.n1238 VDD.n96 0.0300385
R5596 VDD.n1234 VDD.n96 0.0300385
R5597 VDD.n1234 VDD.n1233 0.0300385
R5598 VDD.n1233 VDD.n1232 0.0300385
R5599 VDD.n1228 VDD.n102 0.0300385
R5600 VDD.n1228 VDD.n1227 0.0300385
R5601 VDD.n1227 VDD.n1226 0.0300385
R5602 VDD.n1226 VDD.n93 0.0300385
R5603 VDD.n1244 VDD.n87 0.0300385
R5604 VDD.n1252 VDD.n87 0.0300385
R5605 VDD.n1253 VDD.n1252 0.0300385
R5606 VDD.n1254 VDD.n1253 0.0300385
R5607 VDD.n1262 VDD.n81 0.0300385
R5608 VDD.n1263 VDD.n1262 0.0300385
R5609 VDD.n1265 VDD.n1263 0.0300385
R5610 VDD.n1265 VDD.n1264 0.0300385
R5611 VDD.n1274 VDD.n1273 0.0300385
R5612 VDD.n1275 VDD.n1274 0.0300385
R5613 VDD.n1275 VDD.n69 0.0300385
R5614 VDD.n1283 VDD.n69 0.0300385
R5615 VDD.n1285 VDD.n1284 0.0300385
R5616 VDD.n1285 VDD.n63 0.0300385
R5617 VDD.n1293 VDD.n63 0.0300385
R5618 VDD.n1294 VDD.n1293 0.0300385
R5619 VDD.n1296 VDD.n57 0.0300385
R5620 VDD.n1304 VDD.n57 0.0300385
R5621 VDD.n1305 VDD.n1304 0.0300385
R5622 VDD.n1306 VDD.n1305 0.0300385
R5623 VDD.n1315 VDD.n51 0.0300385
R5624 VDD.n1316 VDD.n1315 0.0300385
R5625 VDD.n1317 VDD.n1316 0.0300385
R5626 VDD.n1317 VDD.n37 0.0300385
R5627 VDD.n1344 VDD.n38 0.0300385
R5628 VDD.n1340 VDD.n38 0.0300385
R5629 VDD.n1340 VDD.n1339 0.0300385
R5630 VDD.n1339 VDD.n1338 0.0300385
R5631 VDD.n1334 VDD.n44 0.0300385
R5632 VDD.n1334 VDD.n1333 0.0300385
R5633 VDD.n1333 VDD.n34 0.0300385
R5634 VDD.n1915 VDD.n34 0.0300385
R5635 VDD.n1590 VDD.n35 0.0300385
R5636 VDD.n1597 VDD.n1590 0.0300385
R5637 VDD.n1598 VDD.n1597 0.0300385
R5638 VDD.n1599 VDD.n1598 0.0300385
R5639 VDD.n1608 VDD.n1584 0.0300385
R5640 VDD.n1609 VDD.n1608 0.0300385
R5641 VDD.n1610 VDD.n1609 0.0300385
R5642 VDD.n1610 VDD.n1348 0.0300385
R5643 VDD.n1910 VDD.n1349 0.0300385
R5644 VDD.n1906 VDD.n1349 0.0300385
R5645 VDD.n1906 VDD.n1905 0.0300385
R5646 VDD.n1905 VDD.n1904 0.0300385
R5647 VDD.n1900 VDD.n1355 0.0300385
R5648 VDD.n1900 VDD.n1899 0.0300385
R5649 VDD.n1899 VDD.n1898 0.0300385
R5650 VDD.n1898 VDD.n1360 0.0300385
R5651 VDD.n1894 VDD.n1893 0.0300385
R5652 VDD.n1893 VDD.n1892 0.0300385
R5653 VDD.n1892 VDD.n1366 0.0300385
R5654 VDD.n1888 VDD.n1366 0.0300385
R5655 VDD.n1888 VDD.n1887 0.0300385
R5656 VDD.n1887 VDD.n1886 0.0300385
R5657 VDD.n1886 VDD.n1371 0.0300385
R5658 VDD.n1882 VDD.n1371 0.0300385
R5659 VDD.n1882 VDD.n1881 0.0300385
R5660 VDD.n1496 VDD.n1376 0.0300385
R5661 VDD.n1629 VDD.n1496 0.0300385
R5662 VDD.n1630 VDD.n1629 0.0300385
R5663 VDD.n1631 VDD.n1630 0.0300385
R5664 VDD.n1640 VDD.n1490 0.0300385
R5665 VDD.n1641 VDD.n1640 0.0300385
R5666 VDD.n1642 VDD.n1641 0.0300385
R5667 VDD.n1642 VDD.n1378 0.0300385
R5668 VDD.n1876 VDD.n1379 0.0300385
R5669 VDD.n1872 VDD.n1379 0.0300385
R5670 VDD.n1872 VDD.n1871 0.0300385
R5671 VDD.n1871 VDD.n1870 0.0300385
R5672 VDD.n1866 VDD.n1385 0.0300385
R5673 VDD.n1866 VDD.n1865 0.0300385
R5674 VDD.n1865 VDD.n1864 0.0300385
R5675 VDD.n1864 VDD.n1390 0.0300385
R5676 VDD.n1860 VDD.n1859 0.0300385
R5677 VDD.n1859 VDD.n1858 0.0300385
R5678 VDD.n1858 VDD.n1396 0.0300385
R5679 VDD.n1854 VDD.n1396 0.0300385
R5680 VDD.n1853 VDD.n1852 0.0300385
R5681 VDD.n1852 VDD.n1401 0.0300385
R5682 VDD.n1848 VDD.n1401 0.0300385
R5683 VDD.n1848 VDD.n1847 0.0300385
R5684 VDD.n1484 VDD.n1406 0.0300385
R5685 VDD.n1681 VDD.n1484 0.0300385
R5686 VDD.n1682 VDD.n1681 0.0300385
R5687 VDD.n1683 VDD.n1682 0.0300385
R5688 VDD.n1692 VDD.n1478 0.0300385
R5689 VDD.n1693 VDD.n1692 0.0300385
R5690 VDD.n1694 VDD.n1693 0.0300385
R5691 VDD.n1694 VDD.n1408 0.0300385
R5692 VDD.n1842 VDD.n1409 0.0300385
R5693 VDD.n1838 VDD.n1409 0.0300385
R5694 VDD.n1838 VDD.n1837 0.0300385
R5695 VDD.n1837 VDD.n1836 0.0300385
R5696 VDD.n1832 VDD.n1415 0.0300385
R5697 VDD.n1832 VDD.n1831 0.0300385
R5698 VDD.n1831 VDD.n1830 0.0300385
R5699 VDD.n1830 VDD.n1420 0.0300385
R5700 VDD.n1826 VDD.n1825 0.0300385
R5701 VDD.n1825 VDD.n1824 0.0300385
R5702 VDD.n1824 VDD.n1426 0.0300385
R5703 VDD.n1820 VDD.n1426 0.0300385
R5704 VDD.n1819 VDD.n1818 0.0300385
R5705 VDD.n1818 VDD.n1431 0.0300385
R5706 VDD.n1814 VDD.n1431 0.0300385
R5707 VDD.n1814 VDD.n1813 0.0300385
R5708 VDD.n1472 VDD.n1436 0.0300385
R5709 VDD.n1731 VDD.n1472 0.0300385
R5710 VDD.n1732 VDD.n1731 0.0300385
R5711 VDD.n1733 VDD.n1732 0.0300385
R5712 VDD.n1742 VDD.n1466 0.0300385
R5713 VDD.n1743 VDD.n1742 0.0300385
R5714 VDD.n1744 VDD.n1743 0.0300385
R5715 VDD.n1744 VDD.n1437 0.0300385
R5716 VDD.n1808 VDD.n1438 0.0300385
R5717 VDD.n1804 VDD.n1438 0.0300385
R5718 VDD.n1804 VDD.n1803 0.0300385
R5719 VDD.n1803 VDD.n1802 0.0300385
R5720 VDD.n1798 VDD.n1444 0.0300385
R5721 VDD.n1798 VDD.n1797 0.0300385
R5722 VDD.n1797 VDD.n1796 0.0300385
R5723 VDD.n1796 VDD.n1449 0.0300385
R5724 VDD.n1792 VDD.n1791 0.0300385
R5725 VDD.n1791 VDD.n1790 0.0300385
R5726 VDD.n1790 VDD.n1455 0.0300385
R5727 VDD.n1786 VDD.n1455 0.0300385
R5728 VDD.n1785 VDD.n1784 0.0300385
R5729 VDD.n1784 VDD.n1460 0.0300385
R5730 VDD.n1780 VDD.n1460 0.0300385
R5731 VDD.n1780 VDD.n2 0.0300385
R5732 VDD.n2243 VDD.n3 0.0300385
R5733 VDD.n2239 VDD.n3 0.0300385
R5734 VDD.n839 VDD.n830 0.0278446
R5735 VDD.n1135 VDD.n1134 0.02679
R5736 VDD.n2221 VDD.n1935 0.02679
R5737 VDD.n662 VDD.n650 0.0179683
R5738 VDD.n664 VDD.n652 0.0179683
R5739 VDD.n666 VDD.n654 0.0179683
R5740 VDD.n667 VDD.n655 0.0179683
R5741 VDD.n669 VDD.n657 0.0179683
R5742 VDD.n671 VDD.n659 0.0179683
R5743 VDD.n636 VDD.n623 0.0179683
R5744 VDD.n637 VDD.n624 0.0179683
R5745 VDD.n639 VDD.n626 0.0179683
R5746 VDD.n641 VDD.n628 0.0179683
R5747 VDD.n643 VDD.n630 0.0179683
R5748 VDD.n644 VDD.n631 0.0179683
R5749 VDD.n646 VDD.n633 0.0179683
R5750 VDD.n675 VDD.n635 0.0179683
R5751 VDD.n637 VDD.n625 0.0179683
R5752 VDD.n639 VDD.n627 0.0179683
R5753 VDD.n640 VDD.n628 0.0179683
R5754 VDD.n642 VDD.n630 0.0179683
R5755 VDD.n644 VDD.n632 0.0179683
R5756 VDD.n646 VDD.n634 0.0179683
R5757 VDD.n647 VDD.n635 0.0179683
R5758 VDD.n662 VDD.n651 0.0179683
R5759 VDD.n663 VDD.n652 0.0179683
R5760 VDD.n665 VDD.n654 0.0179683
R5761 VDD.n667 VDD.n656 0.0179683
R5762 VDD.n669 VDD.n658 0.0179683
R5763 VDD.n670 VDD.n659 0.0179683
R5764 VDD.n720 VDD.n708 0.0179683
R5765 VDD.n722 VDD.n710 0.0179683
R5766 VDD.n724 VDD.n712 0.0179683
R5767 VDD.n725 VDD.n713 0.0179683
R5768 VDD.n727 VDD.n715 0.0179683
R5769 VDD.n729 VDD.n717 0.0179683
R5770 VDD.n694 VDD.n681 0.0179683
R5771 VDD.n695 VDD.n682 0.0179683
R5772 VDD.n697 VDD.n684 0.0179683
R5773 VDD.n699 VDD.n686 0.0179683
R5774 VDD.n701 VDD.n688 0.0179683
R5775 VDD.n702 VDD.n689 0.0179683
R5776 VDD.n704 VDD.n691 0.0179683
R5777 VDD.n733 VDD.n693 0.0179683
R5778 VDD.n695 VDD.n683 0.0179683
R5779 VDD.n697 VDD.n685 0.0179683
R5780 VDD.n698 VDD.n686 0.0179683
R5781 VDD.n700 VDD.n688 0.0179683
R5782 VDD.n702 VDD.n690 0.0179683
R5783 VDD.n704 VDD.n692 0.0179683
R5784 VDD.n705 VDD.n693 0.0179683
R5785 VDD.n720 VDD.n709 0.0179683
R5786 VDD.n721 VDD.n710 0.0179683
R5787 VDD.n723 VDD.n712 0.0179683
R5788 VDD.n725 VDD.n714 0.0179683
R5789 VDD.n727 VDD.n716 0.0179683
R5790 VDD.n728 VDD.n717 0.0179683
R5791 VDD.n778 VDD.n766 0.0179683
R5792 VDD.n780 VDD.n768 0.0179683
R5793 VDD.n782 VDD.n770 0.0179683
R5794 VDD.n783 VDD.n771 0.0179683
R5795 VDD.n785 VDD.n773 0.0179683
R5796 VDD.n787 VDD.n775 0.0179683
R5797 VDD.n752 VDD.n739 0.0179683
R5798 VDD.n753 VDD.n740 0.0179683
R5799 VDD.n755 VDD.n742 0.0179683
R5800 VDD.n757 VDD.n744 0.0179683
R5801 VDD.n759 VDD.n746 0.0179683
R5802 VDD.n760 VDD.n747 0.0179683
R5803 VDD.n762 VDD.n749 0.0179683
R5804 VDD.n791 VDD.n751 0.0179683
R5805 VDD.n753 VDD.n741 0.0179683
R5806 VDD.n755 VDD.n743 0.0179683
R5807 VDD.n756 VDD.n744 0.0179683
R5808 VDD.n758 VDD.n746 0.0179683
R5809 VDD.n760 VDD.n748 0.0179683
R5810 VDD.n762 VDD.n750 0.0179683
R5811 VDD.n763 VDD.n751 0.0179683
R5812 VDD.n778 VDD.n767 0.0179683
R5813 VDD.n779 VDD.n768 0.0179683
R5814 VDD.n781 VDD.n770 0.0179683
R5815 VDD.n783 VDD.n772 0.0179683
R5816 VDD.n785 VDD.n774 0.0179683
R5817 VDD.n786 VDD.n775 0.0179683
R5818 VDD.n518 VDD.n507 0.0179683
R5819 VDD.n520 VDD.n509 0.0179683
R5820 VDD.n522 VDD.n511 0.0179683
R5821 VDD.n523 VDD.n512 0.0179683
R5822 VDD.n525 VDD.n514 0.0179683
R5823 VDD.n527 VDD.n516 0.0179683
R5824 VDD.n557 VDD.n529 0.0179683
R5825 VDD.n531 VDD.n530 0.0179683
R5826 VDD.n535 VDD.n534 0.0179683
R5827 VDD.n539 VDD.n538 0.0179683
R5828 VDD.n543 VDD.n542 0.0179683
R5829 VDD.n545 VDD.n544 0.0179683
R5830 VDD.n549 VDD.n548 0.0179683
R5831 VDD.n553 VDD.n552 0.0179683
R5832 VDD.n532 VDD.n531 0.0179683
R5833 VDD.n536 VDD.n535 0.0179683
R5834 VDD.n538 VDD.n537 0.0179683
R5835 VDD.n542 VDD.n541 0.0179683
R5836 VDD.n546 VDD.n545 0.0179683
R5837 VDD.n550 VDD.n549 0.0179683
R5838 VDD.n552 VDD.n551 0.0179683
R5839 VDD.n518 VDD.n508 0.0179683
R5840 VDD.n519 VDD.n509 0.0179683
R5841 VDD.n521 VDD.n511 0.0179683
R5842 VDD.n523 VDD.n513 0.0179683
R5843 VDD.n525 VDD.n515 0.0179683
R5844 VDD.n526 VDD.n516 0.0179683
R5845 VDD.n461 VDD.n450 0.0179683
R5846 VDD.n463 VDD.n452 0.0179683
R5847 VDD.n465 VDD.n454 0.0179683
R5848 VDD.n466 VDD.n455 0.0179683
R5849 VDD.n468 VDD.n457 0.0179683
R5850 VDD.n470 VDD.n459 0.0179683
R5851 VDD.n500 VDD.n472 0.0179683
R5852 VDD.n474 VDD.n473 0.0179683
R5853 VDD.n478 VDD.n477 0.0179683
R5854 VDD.n482 VDD.n481 0.0179683
R5855 VDD.n486 VDD.n485 0.0179683
R5856 VDD.n488 VDD.n487 0.0179683
R5857 VDD.n492 VDD.n491 0.0179683
R5858 VDD.n496 VDD.n495 0.0179683
R5859 VDD.n475 VDD.n474 0.0179683
R5860 VDD.n479 VDD.n478 0.0179683
R5861 VDD.n481 VDD.n480 0.0179683
R5862 VDD.n485 VDD.n484 0.0179683
R5863 VDD.n489 VDD.n488 0.0179683
R5864 VDD.n493 VDD.n492 0.0179683
R5865 VDD.n495 VDD.n494 0.0179683
R5866 VDD.n461 VDD.n451 0.0179683
R5867 VDD.n462 VDD.n452 0.0179683
R5868 VDD.n464 VDD.n454 0.0179683
R5869 VDD.n466 VDD.n456 0.0179683
R5870 VDD.n468 VDD.n458 0.0179683
R5871 VDD.n469 VDD.n459 0.0179683
R5872 VDD.n404 VDD.n393 0.0179683
R5873 VDD.n406 VDD.n395 0.0179683
R5874 VDD.n408 VDD.n397 0.0179683
R5875 VDD.n409 VDD.n398 0.0179683
R5876 VDD.n411 VDD.n400 0.0179683
R5877 VDD.n413 VDD.n402 0.0179683
R5878 VDD.n443 VDD.n415 0.0179683
R5879 VDD.n417 VDD.n416 0.0179683
R5880 VDD.n421 VDD.n420 0.0179683
R5881 VDD.n425 VDD.n424 0.0179683
R5882 VDD.n429 VDD.n428 0.0179683
R5883 VDD.n431 VDD.n430 0.0179683
R5884 VDD.n435 VDD.n434 0.0179683
R5885 VDD.n439 VDD.n438 0.0179683
R5886 VDD.n418 VDD.n417 0.0179683
R5887 VDD.n422 VDD.n421 0.0179683
R5888 VDD.n424 VDD.n423 0.0179683
R5889 VDD.n428 VDD.n427 0.0179683
R5890 VDD.n432 VDD.n431 0.0179683
R5891 VDD.n436 VDD.n435 0.0179683
R5892 VDD.n438 VDD.n437 0.0179683
R5893 VDD.n404 VDD.n394 0.0179683
R5894 VDD.n405 VDD.n395 0.0179683
R5895 VDD.n407 VDD.n397 0.0179683
R5896 VDD.n409 VDD.n399 0.0179683
R5897 VDD.n411 VDD.n401 0.0179683
R5898 VDD.n412 VDD.n402 0.0179683
R5899 VDD.n663 VDD.n651 0.0178499
R5900 VDD.n665 VDD.n653 0.0178499
R5901 VDD.n668 VDD.n656 0.0178499
R5902 VDD.n670 VDD.n658 0.0178499
R5903 VDD.n660 VDD.n648 0.0178499
R5904 VDD.n638 VDD.n625 0.0178499
R5905 VDD.n640 VDD.n627 0.0178499
R5906 VDD.n642 VDD.n629 0.0178499
R5907 VDD.n645 VDD.n632 0.0178499
R5908 VDD.n647 VDD.n634 0.0178499
R5909 VDD.n676 VDD.n622 0.0178499
R5910 VDD.n636 VDD.n624 0.0178499
R5911 VDD.n638 VDD.n626 0.0178499
R5912 VDD.n641 VDD.n629 0.0178499
R5913 VDD.n643 VDD.n631 0.0178499
R5914 VDD.n645 VDD.n633 0.0178499
R5915 VDD.n676 VDD.n675 0.0178499
R5916 VDD.n661 VDD.n650 0.0178499
R5917 VDD.n664 VDD.n653 0.0178499
R5918 VDD.n666 VDD.n655 0.0178499
R5919 VDD.n668 VDD.n657 0.0178499
R5920 VDD.n671 VDD.n660 0.0178499
R5921 VDD.n721 VDD.n709 0.0178499
R5922 VDD.n723 VDD.n711 0.0178499
R5923 VDD.n726 VDD.n714 0.0178499
R5924 VDD.n728 VDD.n716 0.0178499
R5925 VDD.n718 VDD.n706 0.0178499
R5926 VDD.n696 VDD.n683 0.0178499
R5927 VDD.n698 VDD.n685 0.0178499
R5928 VDD.n700 VDD.n687 0.0178499
R5929 VDD.n703 VDD.n690 0.0178499
R5930 VDD.n705 VDD.n692 0.0178499
R5931 VDD.n734 VDD.n680 0.0178499
R5932 VDD.n694 VDD.n682 0.0178499
R5933 VDD.n696 VDD.n684 0.0178499
R5934 VDD.n699 VDD.n687 0.0178499
R5935 VDD.n701 VDD.n689 0.0178499
R5936 VDD.n703 VDD.n691 0.0178499
R5937 VDD.n734 VDD.n733 0.0178499
R5938 VDD.n719 VDD.n708 0.0178499
R5939 VDD.n722 VDD.n711 0.0178499
R5940 VDD.n724 VDD.n713 0.0178499
R5941 VDD.n726 VDD.n715 0.0178499
R5942 VDD.n729 VDD.n718 0.0178499
R5943 VDD.n779 VDD.n767 0.0178499
R5944 VDD.n781 VDD.n769 0.0178499
R5945 VDD.n784 VDD.n772 0.0178499
R5946 VDD.n786 VDD.n774 0.0178499
R5947 VDD.n776 VDD.n764 0.0178499
R5948 VDD.n754 VDD.n741 0.0178499
R5949 VDD.n756 VDD.n743 0.0178499
R5950 VDD.n758 VDD.n745 0.0178499
R5951 VDD.n761 VDD.n748 0.0178499
R5952 VDD.n763 VDD.n750 0.0178499
R5953 VDD.n792 VDD.n738 0.0178499
R5954 VDD.n752 VDD.n740 0.0178499
R5955 VDD.n754 VDD.n742 0.0178499
R5956 VDD.n757 VDD.n745 0.0178499
R5957 VDD.n759 VDD.n747 0.0178499
R5958 VDD.n761 VDD.n749 0.0178499
R5959 VDD.n792 VDD.n791 0.0178499
R5960 VDD.n777 VDD.n766 0.0178499
R5961 VDD.n780 VDD.n769 0.0178499
R5962 VDD.n782 VDD.n771 0.0178499
R5963 VDD.n784 VDD.n773 0.0178499
R5964 VDD.n787 VDD.n776 0.0178499
R5965 VDD.n519 VDD.n508 0.0178499
R5966 VDD.n521 VDD.n510 0.0178499
R5967 VDD.n524 VDD.n513 0.0178499
R5968 VDD.n526 VDD.n515 0.0178499
R5969 VDD.n528 VDD.n517 0.0178499
R5970 VDD.n533 VDD.n532 0.0178499
R5971 VDD.n537 VDD.n536 0.0178499
R5972 VDD.n541 VDD.n540 0.0178499
R5973 VDD.n547 VDD.n546 0.0178499
R5974 VDD.n551 VDD.n550 0.0178499
R5975 VDD.n555 VDD.n554 0.0178499
R5976 VDD.n530 VDD.n529 0.0178499
R5977 VDD.n534 VDD.n533 0.0178499
R5978 VDD.n540 VDD.n539 0.0178499
R5979 VDD.n544 VDD.n543 0.0178499
R5980 VDD.n548 VDD.n547 0.0178499
R5981 VDD.n554 VDD.n553 0.0178499
R5982 VDD.n507 VDD.n506 0.0178499
R5983 VDD.n520 VDD.n510 0.0178499
R5984 VDD.n522 VDD.n512 0.0178499
R5985 VDD.n524 VDD.n514 0.0178499
R5986 VDD.n527 VDD.n517 0.0178499
R5987 VDD.n462 VDD.n451 0.0178499
R5988 VDD.n464 VDD.n453 0.0178499
R5989 VDD.n467 VDD.n456 0.0178499
R5990 VDD.n469 VDD.n458 0.0178499
R5991 VDD.n471 VDD.n460 0.0178499
R5992 VDD.n476 VDD.n475 0.0178499
R5993 VDD.n480 VDD.n479 0.0178499
R5994 VDD.n484 VDD.n483 0.0178499
R5995 VDD.n490 VDD.n489 0.0178499
R5996 VDD.n494 VDD.n493 0.0178499
R5997 VDD.n498 VDD.n497 0.0178499
R5998 VDD.n473 VDD.n472 0.0178499
R5999 VDD.n477 VDD.n476 0.0178499
R6000 VDD.n483 VDD.n482 0.0178499
R6001 VDD.n487 VDD.n486 0.0178499
R6002 VDD.n491 VDD.n490 0.0178499
R6003 VDD.n497 VDD.n496 0.0178499
R6004 VDD.n450 VDD.n449 0.0178499
R6005 VDD.n463 VDD.n453 0.0178499
R6006 VDD.n465 VDD.n455 0.0178499
R6007 VDD.n467 VDD.n457 0.0178499
R6008 VDD.n470 VDD.n460 0.0178499
R6009 VDD.n405 VDD.n394 0.0178499
R6010 VDD.n407 VDD.n396 0.0178499
R6011 VDD.n410 VDD.n399 0.0178499
R6012 VDD.n412 VDD.n401 0.0178499
R6013 VDD.n414 VDD.n403 0.0178499
R6014 VDD.n419 VDD.n418 0.0178499
R6015 VDD.n423 VDD.n422 0.0178499
R6016 VDD.n427 VDD.n426 0.0178499
R6017 VDD.n433 VDD.n432 0.0178499
R6018 VDD.n437 VDD.n436 0.0178499
R6019 VDD.n441 VDD.n440 0.0178499
R6020 VDD.n416 VDD.n415 0.0178499
R6021 VDD.n420 VDD.n419 0.0178499
R6022 VDD.n426 VDD.n425 0.0178499
R6023 VDD.n430 VDD.n429 0.0178499
R6024 VDD.n434 VDD.n433 0.0178499
R6025 VDD.n440 VDD.n439 0.0178499
R6026 VDD.n393 VDD.n392 0.0178499
R6027 VDD.n406 VDD.n396 0.0178499
R6028 VDD.n408 VDD.n398 0.0178499
R6029 VDD.n410 VDD.n400 0.0178499
R6030 VDD.n413 VDD.n403 0.0178499
R6031 VDD.n1625 VDD.n1510 0.0171144
R6032 VDD.n679 VDD.n677 0.0161466
R6033 VDD.n737 VDD.n735 0.0161466
R6034 VDD.n795 VDD.n793 0.0161466
R6035 VDD.n556 VDD.n386 0.0161466
R6036 VDD.n499 VDD.n388 0.0161466
R6037 VDD.n442 VDD.n390 0.0161466
R6038 VDD.n1499 VDD.n1362 0.0156729
R6039 VDD.n1501 VDD.n1500 0.0156729
R6040 VDD.n1502 VDD.n1368 0.0156729
R6041 VDD.n1504 VDD.n1503 0.0156729
R6042 VDD.n1505 VDD.n1373 0.0156729
R6043 VDD.n1509 VDD.n1506 0.0156729
R6044 VDD.n1509 VDD.n1508 0.0156729
R6045 VDD.n1505 VDD.n1374 0.0156729
R6046 VDD.n1504 VDD.n1372 0.0156729
R6047 VDD.n1502 VDD.n1369 0.0156729
R6048 VDD.n1501 VDD.n1367 0.0156729
R6049 VDD.n1499 VDD.n1363 0.0156729
R6050 VDD.n2238 VDD.n8 0.0155778
R6051 VDD.n1152 VDD.n1151 0.0155778
R6052 VDD.n1154 VDD.n844 0.0152692
R6053 VDD.n1163 VDD.n844 0.0152692
R6054 VDD.n1185 VDD.n1184 0.0152692
R6055 VDD.n1186 VDD.n1185 0.0152692
R6056 VDD.n1239 VDD.n95 0.0152692
R6057 VDD.n1239 VDD.n1238 0.0152692
R6058 VDD.n1243 VDD.n93 0.0152692
R6059 VDD.n1244 VDD.n1243 0.0152692
R6060 VDD.n1264 VDD.n75 0.0152692
R6061 VDD.n1273 VDD.n75 0.0152692
R6062 VDD.n1295 VDD.n1294 0.0152692
R6063 VDD.n1296 VDD.n1295 0.0152692
R6064 VDD.n1345 VDD.n37 0.0152692
R6065 VDD.n1345 VDD.n1344 0.0152692
R6066 VDD.n1915 VDD.n1914 0.0152692
R6067 VDD.n1914 VDD.n35 0.0152692
R6068 VDD.n1911 VDD.n1348 0.0152692
R6069 VDD.n1911 VDD.n1910 0.0152692
R6070 VDD.n1365 VDD.n1360 0.0152692
R6071 VDD.n1894 VDD.n1365 0.0152692
R6072 VDD.n1881 VDD.n1880 0.0152692
R6073 VDD.n1880 VDD.n1376 0.0152692
R6074 VDD.n1877 VDD.n1378 0.0152692
R6075 VDD.n1877 VDD.n1876 0.0152692
R6076 VDD.n1395 VDD.n1390 0.0152692
R6077 VDD.n1860 VDD.n1395 0.0152692
R6078 VDD.n1847 VDD.n1846 0.0152692
R6079 VDD.n1846 VDD.n1406 0.0152692
R6080 VDD.n1843 VDD.n1408 0.0152692
R6081 VDD.n1843 VDD.n1842 0.0152692
R6082 VDD.n1425 VDD.n1420 0.0152692
R6083 VDD.n1826 VDD.n1425 0.0152692
R6084 VDD.n1813 VDD.n1812 0.0152692
R6085 VDD.n1812 VDD.n1436 0.0152692
R6086 VDD.n1809 VDD.n1437 0.0152692
R6087 VDD.n1809 VDD.n1808 0.0152692
R6088 VDD.n1454 VDD.n1449 0.0152692
R6089 VDD.n1792 VDD.n1454 0.0152692
R6090 VDD.n2244 VDD.n2 0.0152692
R6091 VDD.n2244 VDD.n2243 0.0152692
R6092 VDD.n825 VDD.n612 0.0138671
R6093 VDD.n615 VDD.n613 0.0138671
R6094 VDD.n824 VDD.n613 0.0138671
R6095 VDD.n824 VDD.n611 0.0138671
R6096 VDD.n592 VDD.n379 0.0138671
R6097 VDD.n562 VDD.n380 0.0138671
R6098 VDD.n591 VDD.n380 0.0138671
R6099 VDD.n591 VDD.n378 0.0138671
R6100 VDD.n843 VDD.n94 0.0129536
R6101 VDD.n1240 VDD.n94 0.0129536
R6102 VDD.n1242 VDD.n1240 0.0129536
R6103 VDD.n1242 VDD.n1241 0.0129536
R6104 VDD.n1241 VDD.n36 0.0129536
R6105 VDD.n1346 VDD.n36 0.0129536
R6106 VDD.n1913 VDD.n1346 0.0129536
R6107 VDD.n1913 VDD.n1912 0.0129536
R6108 VDD.n1912 VDD.n1347 0.0129536
R6109 VDD.n1879 VDD.n1878 0.0129536
R6110 VDD.n1878 VDD.n1377 0.0129536
R6111 VDD.n1845 VDD.n1377 0.0129536
R6112 VDD.n1845 VDD.n1844 0.0129536
R6113 VDD.n1844 VDD.n1407 0.0129536
R6114 VDD.n1811 VDD.n1407 0.0129536
R6115 VDD.n1811 VDD.n1810 0.0129536
R6116 VDD.n1810 VDD.n1 0.0129536
R6117 VDD.n2245 VDD.n1 0.0129536
R6118 VDD.n1145 VDD.n1144 0.01271
R6119 VDD.n2233 VDD.n2232 0.01271
R6120 VDD.n823 VDD.n614 0.0125
R6121 VDD.n590 VDD.n381 0.0125
R6122 VDD.n1687 VDD.n1686 0.01216
R6123 VDD.n1705 VDD.n1704 0.01216
R6124 VDD.n1718 VDD.n1716 0.01216
R6125 VDD.n1737 VDD.n1736 0.01216
R6126 VDD.n1635 VDD.n1634 0.01216
R6127 VDD.n1621 VDD.n1620 0.01216
R6128 VDD.n1220 VDD.n1219 0.01216
R6129 VDD.n1258 VDD.n1257 0.01216
R6130 VDD.n1280 VDD.n66 0.01216
R6131 VDD.n1310 VDD.n1309 0.01216
R6132 VDD.n1755 VDD.n1754 0.012102
R6133 VDD.n1770 VDD.n1768 0.012102
R6134 VDD.n1653 VDD.n1652 0.012102
R6135 VDD.n1668 VDD.n1666 0.012102
R6136 VDD.n1328 VDD.n1327 0.012102
R6137 VDD.n1603 VDD.n1602 0.012102
R6138 VDD.n1170 VDD.n126 0.012102
R6139 VDD.n1202 VDD.n1201 0.012102
R6140 VDD.n840 VDD 0.0120244
R6141 VDD.n1676 VDD.n1672 0.01106
R6142 VDD.n1677 VDD.n1676 0.01106
R6143 VDD.n1678 VDD.n1677 0.01106
R6144 VDD.n1678 VDD.n1481 0.01106
R6145 VDD.n1686 VDD.n1481 0.01106
R6146 VDD.n1689 VDD.n1687 0.01106
R6147 VDD.n1689 VDD.n1688 0.01106
R6148 VDD.n1688 VDD.n1475 0.01106
R6149 VDD.n1698 VDD.n1475 0.01106
R6150 VDD.n1699 VDD.n1698 0.01106
R6151 VDD.n1700 VDD.n1699 0.01106
R6152 VDD.n1701 VDD.n1700 0.01106
R6153 VDD.n1703 VDD.n1701 0.01106
R6154 VDD.n1704 VDD.n1703 0.01106
R6155 VDD.n1706 VDD.n1705 0.01106
R6156 VDD.n1708 VDD.n1706 0.01106
R6157 VDD.n1709 VDD.n1708 0.01106
R6158 VDD.n1710 VDD.n1709 0.01106
R6159 VDD.n1711 VDD.n1710 0.01106
R6160 VDD.n1713 VDD.n1711 0.01106
R6161 VDD.n1714 VDD.n1713 0.01106
R6162 VDD.n1715 VDD.n1714 0.01106
R6163 VDD.n1716 VDD.n1715 0.01106
R6164 VDD.n1719 VDD.n1718 0.01106
R6165 VDD.n1720 VDD.n1719 0.01106
R6166 VDD.n1721 VDD.n1720 0.01106
R6167 VDD.n1722 VDD.n1721 0.01106
R6168 VDD.n1726 VDD.n1722 0.01106
R6169 VDD.n1727 VDD.n1726 0.01106
R6170 VDD.n1728 VDD.n1727 0.01106
R6171 VDD.n1728 VDD.n1469 0.01106
R6172 VDD.n1736 VDD.n1469 0.01106
R6173 VDD.n1739 VDD.n1737 0.01106
R6174 VDD.n1739 VDD.n1738 0.01106
R6175 VDD.n1738 VDD.n1463 0.01106
R6176 VDD.n1748 VDD.n1463 0.01106
R6177 VDD.n1626 VDD.n1493 0.01106
R6178 VDD.n1634 VDD.n1493 0.01106
R6179 VDD.n1637 VDD.n1635 0.01106
R6180 VDD.n1637 VDD.n1636 0.01106
R6181 VDD.n1636 VDD.n1487 0.01106
R6182 VDD.n1646 VDD.n1487 0.01106
R6183 VDD.n1647 VDD.n1646 0.01106
R6184 VDD.n1648 VDD.n1647 0.01106
R6185 VDD.n1614 VDD.n1581 0.01106
R6186 VDD.n1615 VDD.n1614 0.01106
R6187 VDD.n1616 VDD.n1615 0.01106
R6188 VDD.n1617 VDD.n1616 0.01106
R6189 VDD.n1619 VDD.n1617 0.01106
R6190 VDD.n1620 VDD.n1619 0.01106
R6191 VDD.n1622 VDD.n1621 0.01106
R6192 VDD.n1624 VDD.n1622 0.01106
R6193 VDD.n1215 VDD.n1214 0.01106
R6194 VDD.n1216 VDD.n1215 0.01106
R6195 VDD.n1218 VDD.n1216 0.01106
R6196 VDD.n1219 VDD.n1218 0.01106
R6197 VDD.n1221 VDD.n1220 0.01106
R6198 VDD.n1222 VDD.n1221 0.01106
R6199 VDD.n1223 VDD.n1222 0.01106
R6200 VDD.n1223 VDD.n90 0.01106
R6201 VDD.n1247 VDD.n90 0.01106
R6202 VDD.n1248 VDD.n1247 0.01106
R6203 VDD.n1249 VDD.n1248 0.01106
R6204 VDD.n1249 VDD.n84 0.01106
R6205 VDD.n1257 VDD.n84 0.01106
R6206 VDD.n1259 VDD.n1258 0.01106
R6207 VDD.n1259 VDD.n78 0.01106
R6208 VDD.n1268 VDD.n78 0.01106
R6209 VDD.n1269 VDD.n1268 0.01106
R6210 VDD.n1270 VDD.n1269 0.01106
R6211 VDD.n1270 VDD.n72 0.01106
R6212 VDD.n1278 VDD.n72 0.01106
R6213 VDD.n1279 VDD.n1278 0.01106
R6214 VDD.n1280 VDD.n1279 0.01106
R6215 VDD.n1288 VDD.n66 0.01106
R6216 VDD.n1289 VDD.n1288 0.01106
R6217 VDD.n1290 VDD.n1289 0.01106
R6218 VDD.n1290 VDD.n60 0.01106
R6219 VDD.n1299 VDD.n60 0.01106
R6220 VDD.n1300 VDD.n1299 0.01106
R6221 VDD.n1301 VDD.n1300 0.01106
R6222 VDD.n1301 VDD.n54 0.01106
R6223 VDD.n1309 VDD.n54 0.01106
R6224 VDD.n1312 VDD.n1310 0.01106
R6225 VDD.n1312 VDD.n1311 0.01106
R6226 VDD.n1311 VDD.n48 0.01106
R6227 VDD.n1321 VDD.n48 0.01106
R6228 VDD.n1322 VDD.n1321 0.01106
R6229 VDD.n1149 VDD.n1148 0.01106
R6230 VDD.n1149 VDD.n847 0.01106
R6231 VDD.n1158 VDD.n847 0.01106
R6232 VDD.n1159 VDD.n1158 0.01106
R6233 VDD.n1160 VDD.n1159 0.01106
R6234 VDD.n1160 VDD.n132 0.01106
R6235 VDD.n1168 VDD.n132 0.01106
R6236 VDD.n1773 VDD.n1772 0.01106
R6237 VDD.n1777 VDD.n1773 0.01106
R6238 VDD.n1777 VDD.n1776 0.01106
R6239 VDD.n1776 VDD.n1775 0.01106
R6240 VDD.n1775 VDD.n1774 0.01106
R6241 VDD.n1774 VDD.n10 0.01106
R6242 VDD.n2236 VDD.n10 0.01106
R6243 VDD.n1649 VDD.n1648 0.0110523
R6244 VDD.n1604 VDD.n1581 0.0110523
R6245 VDD.n1749 VDD.n1748 0.0110458
R6246 VDD.n1214 VDD.n1213 0.0110458
R6247 VDD.n1772 VDD.n1771 0.0110414
R6248 VDD.n1169 VDD.n1168 0.0110414
R6249 VDD.n1672 VDD.n1671 0.0110348
R6250 VDD.n1323 VDD.n1322 0.0110348
R6251 VDD.n1750 VDD.n1749 0.0110075
R6252 VDD.n1751 VDD.n1750 0.0110075
R6253 VDD.n1753 VDD.n1751 0.0110075
R6254 VDD.n1754 VDD.n1753 0.0110075
R6255 VDD.n1756 VDD.n1755 0.0110075
R6256 VDD.n1758 VDD.n1756 0.0110075
R6257 VDD.n1759 VDD.n1758 0.0110075
R6258 VDD.n1763 VDD.n1762 0.0110075
R6259 VDD.n1765 VDD.n1763 0.0110075
R6260 VDD.n1766 VDD.n1765 0.0110075
R6261 VDD.n1767 VDD.n1766 0.0110075
R6262 VDD.n1768 VDD.n1767 0.0110075
R6263 VDD.n1771 VDD.n1770 0.0110075
R6264 VDD.n1651 VDD.n1649 0.0110075
R6265 VDD.n1652 VDD.n1651 0.0110075
R6266 VDD.n1654 VDD.n1653 0.0110075
R6267 VDD.n1656 VDD.n1654 0.0110075
R6268 VDD.n1657 VDD.n1656 0.0110075
R6269 VDD.n1658 VDD.n1657 0.0110075
R6270 VDD.n1659 VDD.n1658 0.0110075
R6271 VDD.n1664 VDD.n1663 0.0110075
R6272 VDD.n1665 VDD.n1664 0.0110075
R6273 VDD.n1666 VDD.n1665 0.0110075
R6274 VDD.n1669 VDD.n1668 0.0110075
R6275 VDD.n1670 VDD.n1669 0.0110075
R6276 VDD.n1671 VDD.n1670 0.0110075
R6277 VDD.n1324 VDD.n1323 0.0110075
R6278 VDD.n1326 VDD.n1324 0.0110075
R6279 VDD.n1327 VDD.n1326 0.0110075
R6280 VDD.n1329 VDD.n1328 0.0110075
R6281 VDD.n1330 VDD.n1329 0.0110075
R6282 VDD.n1330 VDD.n28 0.0110075
R6283 VDD.n1918 VDD.n29 0.0110075
R6284 VDD.n1593 VDD.n29 0.0110075
R6285 VDD.n1594 VDD.n1593 0.0110075
R6286 VDD.n1594 VDD.n1587 0.0110075
R6287 VDD.n1602 VDD.n1587 0.0110075
R6288 VDD.n1605 VDD.n1603 0.0110075
R6289 VDD.n1605 VDD.n1604 0.0110075
R6290 VDD.n1170 VDD.n1169 0.0110075
R6291 VDD.n1178 VDD.n126 0.0110075
R6292 VDD.n1179 VDD.n1178 0.0110075
R6293 VDD.n1180 VDD.n1179 0.0110075
R6294 VDD.n1180 VDD.n120 0.0110075
R6295 VDD.n1189 VDD.n120 0.0110075
R6296 VDD.n1193 VDD.n1192 0.0110075
R6297 VDD.n1193 VDD.n114 0.0110075
R6298 VDD.n1201 VDD.n114 0.0110075
R6299 VDD.n1204 VDD.n1202 0.0110075
R6300 VDD.n1204 VDD.n1203 0.0110075
R6301 VDD.n1203 VDD.n108 0.0110075
R6302 VDD.n1213 VDD.n108 0.0110075
R6303 VDD.n1626 VDD.n1625 0.01095
R6304 VDD.n1625 VDD.n1624 0.01095
R6305 VDD.n1762 VDD.n1761 0.0105697
R6306 VDD.n1191 VDD.n1189 0.0105697
R6307 VDD.n346 VDD 0.0095
R6308 VDD.n674 VDD.n623 0.00929337
R6309 VDD.n732 VDD.n681 0.00929337
R6310 VDD.n790 VDD.n739 0.00929337
R6311 VDD.n558 VDD.n557 0.00929337
R6312 VDD.n501 VDD.n500 0.00929337
R6313 VDD.n444 VDD.n443 0.00929337
R6314 VDD.n1663 VDD.n1661 0.00925622
R6315 VDD.n1919 VDD.n28 0.00925622
R6316 VDD.n661 VDD.n649 0.00917495
R6317 VDD.n677 VDD.n622 0.00917495
R6318 VDD.n673 VDD.n648 0.00917495
R6319 VDD.n719 VDD.n707 0.00917495
R6320 VDD.n735 VDD.n680 0.00917495
R6321 VDD.n731 VDD.n706 0.00917495
R6322 VDD.n777 VDD.n765 0.00917495
R6323 VDD.n793 VDD.n738 0.00917495
R6324 VDD.n789 VDD.n764 0.00917495
R6325 VDD.n560 VDD.n506 0.00917495
R6326 VDD.n556 VDD.n555 0.00917495
R6327 VDD.n559 VDD.n528 0.00917495
R6328 VDD.n503 VDD.n449 0.00917495
R6329 VDD.n499 VDD.n498 0.00917495
R6330 VDD.n502 VDD.n471 0.00917495
R6331 VDD.n446 VDD.n392 0.00917495
R6332 VDD.n442 VDD.n441 0.00917495
R6333 VDD.n445 VDD.n414 0.00917495
R6334 VDD.n842 VDD.n841 0.00855413
R6335 VDD.n829 VDD.n0 0.00855413
R6336 VDD.n612 VDD.n610 0.00760506
R6337 VDD.n826 VDD.n825 0.00760506
R6338 VDD.n379 VDD.n377 0.00760506
R6339 VDD.n593 VDD.n592 0.00760506
R6340 VDD.n805 VDD.n798 0.00750498
R6341 VDD.n798 VDD.n797 0.00750498
R6342 VDD.n810 VDD.n797 0.00750498
R6343 VDD.n808 VDD.n807 0.00750498
R6344 VDD.n583 VDD.n575 0.00750498
R6345 VDD.n577 VDD.n575 0.00750498
R6346 VDD.n578 VDD.n577 0.00750498
R6347 VDD.n581 VDD.n580 0.00750498
R6348 VDD.n616 VDD.n614 0.00696817
R6349 VDD.n822 VDD.n821 0.00696817
R6350 VDD.n823 VDD.n822 0.00696817
R6351 VDD.n563 VDD.n382 0.00696817
R6352 VDD.n590 VDD.n589 0.00696817
R6353 VDD.n382 VDD.n381 0.00696817
R6354 VDD.n1879 VDD 0.00666262
R6355 VDD.n649 VDD.n620 0.00642672
R6356 VDD.n707 VDD.n619 0.00642672
R6357 VDD.n765 VDD.n618 0.00642672
R6358 VDD.n561 VDD.n560 0.00642672
R6359 VDD.n504 VDD.n503 0.00642672
R6360 VDD.n447 VDD.n446 0.00642672
R6361 VDD.n215 VDD.n207 0.00627049
R6362 VDD.n322 VDD.n315 0.00627049
R6363 VDD.n800 VDD.n799 0.00619272
R6364 VDD.n584 VDD.n574 0.00619272
R6365 VDD.n576 VDD.n384 0.00619272
R6366 VDD.n373 VDD.n369 0.0052751
R6367 VDD.n606 VDD.n602 0.00519752
R6368 VDD.n807 VDD.n806 0.00446207
R6369 VDD.n809 VDD.n808 0.00446207
R6370 VDD.n582 VDD.n581 0.00446207
R6371 VDD.n580 VDD.n579 0.00446207
R6372 VDD.n799 VDD.n796 0.00383292
R6373 VDD.n811 VDD.n796 0.00383292
R6374 VDD.n804 VDD.n800 0.00383292
R6375 VDD.n574 VDD.n383 0.00383292
R6376 VDD.n576 VDD.n383 0.00383292
R6377 VDD.n841 VDD.n595 0.00335975
R6378 VDD.n829 VDD.n828 0.00335975
R6379 VDD VDD.n2245 0.00260556
R6380 VDD.n1661 VDD.n1659 0.00225124
R6381 VDD.n1919 VDD.n1918 0.00225124
R6382 VDD.n2227 VDD.n19 0.00192306
R6383 VDD.n1923 VDD.n21 0.001524
R6384 VDD.n2225 VDD.n20 0.00138447
R6385 VDD.n837 VDD.n833 0.00108488
R6386 VDD.n2228 VDD.n2227 0.00107692
R6387 VDD.n1924 VDD.n1923 0.001
R6388 VDD.n18 VDD.n16 0.001
R6389 VDD.n1925 VDD.n19 0.001
R6390 VDD.n2226 VDD.n1926 0.001
R6391 VDD.n1926 VDD.n1925 0.001
R6392 VDD.n2226 VDD.n2225 0.001
R6393 VDD.n1924 VDD.n16 0.001
R6394 VDD.n2228 VDD.n18 0.001
R6395 VDD.n1761 VDD.n1759 0.000937811
R6396 VDD.n1192 VDD.n1191 0.000937811
R6397 VDD VDD.n1347 0.000589872
R6398 VSS.t321 VSS.t336 40489.9
R6399 VSS.t165 VSS.t157 33782.6
R6400 VSS.t307 VSS.t306 33782.6
R6401 VSS.n583 VSS.n582 32559.7
R6402 VSS.n370 VSS.n322 32559.7
R6403 VSS.n583 VSS.t157 23267
R6404 VSS.t306 VSS.n322 23267
R6405 VSS.n581 VSS.t165 7304.35
R6406 VSS.n369 VSS.t307 7304.35
R6407 VSS.n409 VSS.t166 2202.72
R6408 VSS.n772 VSS.n265 1052.96
R6409 VSS.n410 VSS.n409 1052.56
R6410 VSS.n367 VSS.n330 1052.13
R6411 VSS.t166 VSS.n52 869.501
R6412 VSS.n75 VSS.t8 788.322
R6413 VSS.n1990 VSS.t148 788.322
R6414 VSS.n773 VSS.n772 691.125
R6415 VSS.n330 VSS.n329 691.125
R6416 VSS.n330 VSS.n302 640.449
R6417 VSS.t336 VSS.t9 616.843
R6418 VSS.n409 VSS.t321 597.264
R6419 VSS.n1022 VSS.n773 482.332
R6420 VSS.n456 VSS.n382 418.632
R6421 VSS.n556 VSS.n555 418.065
R6422 VSS.n772 VSS.n771 414.913
R6423 VSS.n641 VSS.t285 334.505
R6424 VSS.t349 VSS.n600 334.505
R6425 VSS.n604 VSS.n600 304.572
R6426 VSS.t316 VSS.n604 267.985
R6427 VSS.t134 VSS.n402 217.125
R6428 VSS.t173 VSS.n489 216.448
R6429 VSS.t168 VSS.n486 212.374
R6430 VSS.t139 VSS.n396 211.68
R6431 VSS.t136 VSS.n400 211.68
R6432 VSS.t171 VSS.n491 211.68
R6433 VSS.t138 VSS.n398 206.912
R6434 VSS.t169 VSS.n264 206.912
R6435 VSS.n396 VSS.t140 202.145
R6436 VSS.t135 VSS.n400 202.145
R6437 VSS.t172 VSS.n491 202.145
R6438 VSS.t174 VSS.n489 197.377
R6439 VSS.n1022 VSS.n258 185.425
R6440 VSS.t344 VSS.t346 182.774
R6441 VSS.t341 VSS.t343 182.774
R6442 VSS.t338 VSS.t340 182.774
R6443 VSS.t297 VSS.t337 182.774
R6444 VSS.t294 VSS.t296 182.774
R6445 VSS.t291 VSS.t293 182.774
R6446 VSS.t288 VSS.t290 182.774
R6447 VSS.n616 VSS.t347 179.623
R6448 VSS.t287 VSS.n637 179.623
R6449 VSS.t176 VSS.n76 171.102
R6450 VSS.t256 VSS.n73 170.127
R6451 VSS.t347 VSS.n615 160.714
R6452 VSS.n638 VSS.t287 160.714
R6453 VSS.n581 VSS.n265 160.47
R6454 VSS.n410 VSS.n398 159.238
R6455 VSS.n773 VSS.n264 159.238
R6456 VSS.n620 VSS.t344 154.412
R6457 VSS.t290 VSS.n632 154.412
R6458 VSS.n369 VSS.n368 154.23
R6459 VSS.n641 VSS.n640 143.856
R6460 VSS.n621 VSS.t341 129.202
R6461 VSS.t293 VSS.n631 129.202
R6462 VSS.n49 VSS.t11 120.93
R6463 VSS.t185 VSS.t184 114.249
R6464 VSS.t182 VSS.t181 114.249
R6465 VSS.t179 VSS.t178 114.249
R6466 VSS.t254 VSS.t253 114.249
R6467 VSS.t251 VSS.t250 114.249
R6468 VSS.t248 VSS.t247 114.249
R6469 VSS.t187 VSS.n80 112.278
R6470 VSS.n102 VSS.t245 112.278
R6471 VSS.n76 VSS.n75 111.228
R6472 VSS.n1995 VSS.n1990 109.325
R6473 VSS.n626 VSS.t338 103.993
R6474 VSS.t296 VSS.n627 103.993
R6475 VSS.n56 VSS.t121 97.5929
R6476 VSS.t184 VSS.n79 96.5205
R6477 VSS.n105 VSS.t248 96.5205
R6478 VSS.t128 VSS.n52 94.2769
R6479 VSS.n1413 VSS.n71 91.5807
R6480 VSS.n176 VSS.n122 91.5797
R6481 VSS.t174 VSS.n488 91.0964
R6482 VSS.n1413 VSS.n33 89.456
R6483 VSS.n176 VSS.n118 89.456
R6484 VSS.n441 VSS.t140 86.3255
R6485 VSS.t172 VSS.n490 86.2708
R6486 VSS.t135 VSS.n401 86.2698
R6487 VSS.n81 VSS.t187 81.994
R6488 VSS.t245 VSS.n101 81.994
R6489 VSS.t137 VSS.n399 81.5032
R6490 VSS.t138 VSS.n397 81.5032
R6491 VSS.n492 VSS.t170 81.5022
R6492 VSS.n559 VSS.t169 81.5022
R6493 VSS.n416 VSS.t141 81.3214
R6494 VSS.t175 VSS.n532 81.2508
R6495 VSS.n329 VSS.n57 81.0518
R6496 VSS.t181 VSS.n78 80.7622
R6497 VSS.n106 VSS.t251 80.7622
R6498 VSS.t337 VSS.n626 78.782
R6499 VSS.n627 VSS.t297 78.782
R6500 VSS.n536 VSS.t173 77.5059
R6501 VSS.n414 VSS.t134 77.5059
R6502 VSS.t171 VSS.n492 76.7356
R6503 VSS.n559 VSS.t168 76.7356
R6504 VSS.t139 VSS.n397 76.7346
R6505 VSS.t136 VSS.n399 76.7346
R6506 VSS.t171 VSS.n534 75.9575
R6507 VSS.t168 VSS.n558 75.9575
R6508 VSS.t139 VSS.n405 75.9575
R6509 VSS.n412 VSS.t136 75.9575
R6510 VSS.t169 VSS.n263 74.4092
R6511 VSS.n407 VSS.t138 74.4092
R6512 VSS.n298 VSS.t315 74.0619
R6513 VSS.n57 VSS.t334 73.3326
R6514 VSS.n534 VSS.t172 72.8608
R6515 VSS.n558 VSS.t167 72.8608
R6516 VSS.n405 VSS.t140 72.8608
R6517 VSS.t135 VSS.n412 72.8608
R6518 VSS.t26 VSS.n33 72.2043
R6519 VSS.n118 VSS.t61 72.2043
R6520 VSS.t134 VSS.n401 71.968
R6521 VSS.t173 VSS.n490 71.967
R6522 VSS.t174 VSS.n536 71.3124
R6523 VSS.t133 VSS.n414 71.3124
R6524 VSS.t132 VSS.n53 71.1194
R6525 VSS.n67 VSS.t25 69.0073
R6526 VSS.t63 VSS.n112 69.0073
R6527 VSS.t5 VSS.t6 68.1295
R6528 VSS.t0 VSS.t1 68.1295
R6529 VSS.t263 VSS.t264 68.1295
R6530 VSS.t258 VSS.t259 68.1295
R6531 VSS.t159 VSS.n579 67.3553
R6532 VSS.n372 VSS.t304 67.3553
R6533 VSS.n408 VSS.t265 66.9762
R6534 VSS.n565 VSS.t7 65.8069
R6535 VSS.t257 VSS.n381 65.8069
R6536 VSS.t178 VSS.n77 65.0038
R6537 VSS.n107 VSS.t254 65.0038
R6538 VSS.t244 VSS.t242 64.433
R6539 VSS.t241 VSS.t239 64.433
R6540 VSS.t229 VSS.t227 64.433
R6541 VSS.t218 VSS.t217 64.433
R6542 VSS.t215 VSS.t214 64.433
R6543 VSS.t205 VSS.t203 64.433
R6544 VSS.t193 VSS.t191 64.433
R6545 VSS.t190 VSS.t188 64.433
R6546 VSS.t314 VSS.n298 63.3889
R6547 VSS.t133 VSS.n402 62.1162
R6548 VSS.n56 VSS.t132 61.2025
R6549 VSS.t334 VSS.n50 60.6411
R6550 VSS.n281 VSS.t312 60.5032
R6551 VSS.t167 VSS.n486 60.2877
R6552 VSS.n571 VSS.t2 59.6134
R6553 VSS.t262 VSS.n377 59.6134
R6554 VSS.n773 VSS.n263 58.9253
R6555 VSS.n410 VSS.n407 58.9253
R6556 VSS.n64 VSS.t20 57.676
R6557 VSS.n61 VSS.t16 57.676
R6558 VSS.t313 VSS.n281 56.9469
R6559 VSS.t328 VSS.t230 56.6567
R6560 VSS.t202 VSS.t327 56.6567
R6561 VSS.t4 VSS.n566 54.9682
R6562 VSS.n380 VSS.t260 54.9682
R6563 VSS.t340 VSS.n621 53.5719
R6564 VSS.n631 VSS.t294 53.5719
R6565 VSS.n578 VSS.t162 53.4199
R6566 VSS.t160 VSS.t278 53.4199
R6567 VSS.t274 VSS.t303 53.4199
R6568 VSS.t301 VSS.n373 53.4199
R6569 VSS.t317 VSS.n287 53.2042
R6570 VSS.n329 VSS.n49 53.111
R6571 VSS.n96 VSS.t229 52.2131
R6572 VSS.t203 VSS.n86 52.2131
R6573 VSS.t158 VSS.n580 51.8715
R6574 VSS.n371 VSS.t305 51.8715
R6575 VSS.n53 VSS.t128 51.2701
R6576 VSS.t17 VSS.n41 50.4666
R6577 VSS.t13 VSS.n45 50.4666
R6578 VSS.t22 VSS.n37 50.4666
R6579 VSS.n77 VSS.t176 49.2454
R6580 VSS.n107 VSS.t256 49.2454
R6581 VSS.t143 VSS.t220 48.3249
R6582 VSS.t212 VSS.t153 48.3249
R6583 VSS.t242 VSS.n100 47.7694
R6584 VSS.t330 VSS.t233 47.7694
R6585 VSS.t199 VSS.t325 47.7694
R6586 VSS.n82 VSS.t190 47.7694
R6587 VSS.t163 VSS.n575 45.6779
R6588 VSS.n375 VSS.t300 45.6779
R6589 VSS.n570 VSS.t3 44.1295
R6590 VSS.t261 VSS.n378 44.1295
R6591 VSS.n97 VSS.t232 43.3258
R6592 VSS.t200 VSS.n85 43.3258
R6593 VSS.n278 VSS.t266 42.6869
R6594 VSS.t310 VSS.n301 42.3454
R6595 VSS.t332 VSS.t236 38.8822
R6596 VSS.t196 VSS.t323 38.8822
R6597 VSS.n537 VSS.t174 38.5166
R6598 VSS.n415 VSS.t133 38.5157
R6599 VSS.n299 VSS.t314 38.4888
R6600 VSS.t155 VSS.n286 37.4956
R6601 VSS.t140 VSS.n388 37.2263
R6602 VSS.t167 VSS.n557 37.2253
R6603 VSS.t145 VSS.t223 37.2158
R6604 VSS.t209 VSS.t151 37.2158
R6605 VSS.t172 VSS.n533 36.9682
R6606 VSS.n413 VSS.t135 36.9673
R6607 VSS.t121 VSS.n50 36.3818
R6608 VSS.t23 VSS.n37 36.0479
R6609 VSS.t19 VSS.n41 36.0479
R6610 VSS.t14 VSS.n45 36.0479
R6611 VSS.t138 VSS.n406 35.4198
R6612 VSS.n535 VSS.t170 35.4198
R6613 VSS.n493 VSS.t169 35.4189
R6614 VSS.n411 VSS.t137 35.4189
R6615 VSS.n95 VSS.t147 34.994
R6616 VSS.t149 VSS.n87 34.994
R6617 VSS.n286 VSS.t318 34.7627
R6618 VSS.n1997 VSS.n37 34.5695
R6619 VSS.n1997 VSS.n41 34.5695
R6620 VSS.n1997 VSS.n45 34.5695
R6621 VSS.n98 VSS.t235 34.4386
R6622 VSS.t197 VSS.n84 34.4386
R6623 VSS.n302 VSS.t308 34.098
R6624 VSS.t164 VSS.t276 34.065
R6625 VSS.t267 VSS.t299 34.065
R6626 VSS.t136 VSS.n411 33.8714
R6627 VSS.t168 VSS.n493 33.8714
R6628 VSS.n535 VSS.t171 33.8705
R6629 VSS.n406 VSS.t139 33.8705
R6630 VSS.n67 VSS.t23 33.7208
R6631 VSS.n78 VSS.t179 33.487
R6632 VSS.t253 VSS.n106 33.487
R6633 VSS.t308 VSS.n276 33.4134
R6634 VSS.n577 VSS.t280 33.2908
R6635 VSS.t272 VSS.n374 33.2908
R6636 VSS.n258 VSS.n112 33.0663
R6637 VSS.n1997 VSS.n64 33.0636
R6638 VSS.t226 VSS.t146 32.7722
R6639 VSS.t150 VSS.t206 32.7722
R6640 VSS.n770 VSS.t318 32.7346
R6641 VSS.n640 VSS.n280 32.5599
R6642 VSS.t134 VSS.n413 32.3231
R6643 VSS.t173 VSS.n533 32.3221
R6644 VSS.t217 VSS.n91 32.2168
R6645 VSS.n91 VSS.t215 32.2168
R6646 VSS.t141 VSS.n415 30.7747
R6647 VSS.n537 VSS.t175 30.7737
R6648 VSS.t142 VSS.n92 30.5504
R6649 VSS.n90 VSS.t154 30.5504
R6650 VSS.t162 VSS.n577 30.194
R6651 VSS.n374 VSS.t301 30.194
R6652 VSS.t239 VSS.t333 29.9949
R6653 VSS.t322 VSS.t193 29.9949
R6654 VSS.n287 VSS.t155 29.9818
R6655 VSS.n593 VSS.n276 29.7306
R6656 VSS.n39 VSS.t22 29.4442
R6657 VSS.n43 VSS.t17 29.4442
R6658 VSS.n47 VSS.t13 29.4442
R6659 VSS.n35 VSS.t26 29.075
R6660 VSS.t61 VSS.n115 29.075
R6661 VSS.n61 VSS.t14 28.8393
R6662 VSS.n64 VSS.t19 28.8385
R6663 VSS.n567 VSS.t4 28.6457
R6664 VSS.t260 VSS.n379 28.6457
R6665 VSS.t343 VSS.n620 28.3618
R6666 VSS.n632 VSS.t291 28.3618
R6667 VSS.t144 VSS.n93 28.3286
R6668 VSS.n89 VSS.t152 28.3286
R6669 VSS.t315 VSS.n297 27.8158
R6670 VSS.t224 VSS.t145 27.2177
R6671 VSS.t151 VSS.t208 27.2177
R6672 VSS.t276 VSS.n574 27.0973
R6673 VSS.n376 VSS.t267 27.0973
R6674 VSS.t311 VSS.n279 26.6368
R6675 VSS.n612 VSS.n289 26.2303
R6676 VSS.n611 VSS.n290 26.2303
R6677 VSS.n610 VSS.n291 26.2303
R6678 VSS.n609 VSS.n292 26.2303
R6679 VSS.n608 VSS.n293 26.2303
R6680 VSS.n607 VSS.n294 26.2303
R6681 VSS.n603 VSS.n296 26.2303
R6682 VSS.n708 VSS.n300 26.2303
R6683 VSS.n599 VSS.n306 26.2303
R6684 VSS.n590 VSS.n273 26.2303
R6685 VSS.n598 VSS.n305 26.2303
R6686 VSS.n591 VSS.n274 26.2303
R6687 VSS.n592 VSS.n275 26.2303
R6688 VSS.n595 VSS.n303 26.2303
R6689 VSS.t147 VSS.t226 26.1068
R6690 VSS.t146 VSS.n94 26.1068
R6691 VSS.n88 VSS.t150 26.1068
R6692 VSS.t206 VSS.t149 26.1068
R6693 VSS.n99 VSS.t238 25.5513
R6694 VSS.t238 VSS.t332 25.5513
R6695 VSS.t323 VSS.t194 25.5513
R6696 VSS.t194 VSS.n83 25.5513
R6697 VSS.n368 VSS.n367 25.2708
R6698 VSS.n382 VSS.t257 25.1502
R6699 VSS.n299 VSS.t313 24.9301
R6700 VSS.t283 VSS.n567 24.3876
R6701 VSS.n379 VSS.t269 24.3876
R6702 VSS.t2 VSS.n570 24.0005
R6703 VSS.n378 VSS.t262 24.0005
R6704 VSS.n604 VSS.n297 23.7443
R6705 VSS.t7 VSS.n480 23.7137
R6706 VSS.n611 VSS.n289 23.4984
R6707 VSS.n610 VSS.n290 23.4984
R6708 VSS.n609 VSS.n291 23.4984
R6709 VSS.n608 VSS.n292 23.4984
R6710 VSS.n607 VSS.n293 23.4984
R6711 VSS.n605 VSS.n294 23.4984
R6712 VSS.n603 VSS.n295 23.4984
R6713 VSS.n602 VSS.n296 23.4984
R6714 VSS.n588 VSS.n300 23.4984
R6715 VSS.n590 VSS.n306 23.4984
R6716 VSS.n598 VSS.n273 23.4984
R6717 VSS.n591 VSS.n305 23.4984
R6718 VSS.n596 VSS.n274 23.4984
R6719 VSS.n595 VSS.n275 23.4984
R6720 VSS.n593 VSS.n303 23.4984
R6721 VSS.n92 VSS.t218 23.3295
R6722 VSS.t214 VSS.n90 23.3295
R6723 VSS.n1997 VSS.n61 22.5643
R6724 VSS.n575 VSS.t164 22.4521
R6725 VSS.t299 VSS.n375 22.4521
R6726 VSS.n615 VSS.t349 22.0593
R6727 VSS.t285 VSS.n638 22.0593
R6728 VSS.t316 VSS.n295 21.7909
R6729 VSS.t223 VSS.t144 21.6632
R6730 VSS.t152 VSS.t209 21.6632
R6731 VSS.t312 VSS.n280 21.3737
R6732 VSS.t236 VSS.t331 21.1077
R6733 VSS.t324 VSS.t196 21.1077
R6734 VSS.n582 VSS.t158 20.5166
R6735 VSS.t305 VSS.n370 20.5166
R6736 VSS.t25 VSS.n35 20.4492
R6737 VSS.n115 VSS.t63 20.4492
R6738 VSS.t20 VSS.n39 19.6279
R6739 VSS.t16 VSS.n43 19.6279
R6740 VSS.t11 VSS.n47 19.6279
R6741 VSS.n1990 VSS.n122 18.6203
R6742 VSS.n75 VSS.n71 18.6194
R6743 VSS.n79 VSS.t182 17.7287
R6744 VSS.t250 VSS.n105 17.7287
R6745 VSS.n29 VSS.t335 17.6124
R6746 VSS.n466 VSS.n322 17.0005
R6747 VSS.n583 VSS.n573 17.0005
R6748 VSS.n561 VSS.n560 17.0005
R6749 VSS.n709 VSS.n602 17.0005
R6750 VSS.n709 VSS.n603 17.0005
R6751 VSS.n709 VSS.n605 17.0005
R6752 VSS.n709 VSS.n607 17.0005
R6753 VSS.n709 VSS.n608 17.0005
R6754 VSS.n709 VSS.n609 17.0005
R6755 VSS.n709 VSS.n610 17.0005
R6756 VSS.n709 VSS.n611 17.0005
R6757 VSS.n769 VSS.n288 17.0005
R6758 VSS.n709 VSS.n612 17.0005
R6759 VSS.n709 VSS.n638 17.0005
R6760 VSS.n709 VSS.n636 17.0005
R6761 VSS.n709 VSS.n637 17.0005
R6762 VSS.n709 VSS.n634 17.0005
R6763 VSS.n709 VSS.n632 17.0005
R6764 VSS.n709 VSS.n630 17.0005
R6765 VSS.n709 VSS.n631 17.0005
R6766 VSS.n709 VSS.n628 17.0005
R6767 VSS.n709 VSS.n627 17.0005
R6768 VSS.n709 VSS.n625 17.0005
R6769 VSS.n709 VSS.n626 17.0005
R6770 VSS.n709 VSS.n623 17.0005
R6771 VSS.n709 VSS.n621 17.0005
R6772 VSS.n709 VSS.n619 17.0005
R6773 VSS.n709 VSS.n620 17.0005
R6774 VSS.n709 VSS.n617 17.0005
R6775 VSS.n709 VSS.n616 17.0005
R6776 VSS.n709 VSS.n615 17.0005
R6777 VSS.n709 VSS.n593 17.0005
R6778 VSS.n709 VSS.n595 17.0005
R6779 VSS.n709 VSS.n592 17.0005
R6780 VSS.n709 VSS.n596 17.0005
R6781 VSS.n709 VSS.n591 17.0005
R6782 VSS.n709 VSS.n598 17.0005
R6783 VSS.n709 VSS.n590 17.0005
R6784 VSS.n709 VSS.n599 17.0005
R6785 VSS.n709 VSS.n588 17.0005
R6786 VSS.n709 VSS.n708 17.0005
R6787 VSS.n769 VSS.n279 17.0005
R6788 VSS.n769 VSS.n278 17.0005
R6789 VSS.n769 VSS.n301 17.0005
R6790 VSS.n769 VSS.n304 17.0005
R6791 VSS.n769 VSS.n272 17.0005
R6792 VSS.n1997 VSS.n56 17.0005
R6793 VSS.n1997 VSS.n57 17.0005
R6794 VSS.n1997 VSS.n121 17.0005
R6795 VSS.n1997 VSS.n117 17.0005
R6796 VSS.n1997 VSS.n116 17.0005
R6797 VSS.n1997 VSS.n114 17.0005
R6798 VSS.n1997 VSS.n113 17.0005
R6799 VSS.n1997 VSS.n111 17.0005
R6800 VSS.n1997 VSS.n112 17.0005
R6801 VSS.n1997 VSS.n110 17.0005
R6802 VSS.n1997 VSS.n108 17.0005
R6803 VSS.n1024 VSS.n231 17.0005
R6804 VSS.n1025 VSS.n1024 17.0005
R6805 VSS.n918 VSS.n257 17.0005
R6806 VSS.n916 VSS.n257 17.0005
R6807 VSS.n892 VSS.n891 17.0005
R6808 VSS.n891 VSS.n890 17.0005
R6809 VSS.n872 VSS.n871 17.0005
R6810 VSS.n871 VSS.n870 17.0005
R6811 VSS.n852 VSS.n851 17.0005
R6812 VSS.n851 VSS.n850 17.0005
R6813 VSS.n775 VSS.n774 17.0005
R6814 VSS.n1997 VSS.n28 17.0005
R6815 VSS.n1997 VSS.n58 17.0005
R6816 VSS.n1997 VSS.n48 17.0005
R6817 VSS.n1997 VSS.n59 17.0005
R6818 VSS.n1997 VSS.n46 17.0005
R6819 VSS.n1997 VSS.n60 17.0005
R6820 VSS.n1997 VSS.n44 17.0005
R6821 VSS.n1997 VSS.n62 17.0005
R6822 VSS.n1997 VSS.n42 17.0005
R6823 VSS.n1997 VSS.n63 17.0005
R6824 VSS.n1997 VSS.n40 17.0005
R6825 VSS.n1997 VSS.n65 17.0005
R6826 VSS.n1997 VSS.n38 17.0005
R6827 VSS.n1997 VSS.n66 17.0005
R6828 VSS.n1997 VSS.n67 17.0005
R6829 VSS.n1997 VSS.n36 17.0005
R6830 VSS.n1997 VSS.n68 17.0005
R6831 VSS.n1997 VSS.n34 17.0005
R6832 VSS.n1997 VSS.n69 17.0005
R6833 VSS.n1997 VSS.n70 17.0005
R6834 VSS.n588 VSS.n272 16.7336
R6835 VSS.n596 VSS.n304 16.7336
R6836 VSS.n100 VSS.t241 16.6641
R6837 VSS.t235 VSS.t330 16.6641
R6838 VSS.t325 VSS.t197 16.6641
R6839 VSS.t191 VSS.n82 16.6641
R6840 VSS.n582 VSS.n581 16.3053
R6841 VSS.n370 VSS.n369 16.3053
R6842 VSS.n580 VSS.t159 16.2586
R6843 VSS.t304 VSS.n371 16.2586
R6844 VSS.t221 VSS.t143 16.1086
R6845 VSS.t153 VSS.t211 16.1086
R6846 VSS.t3 VSS.t283 15.0973
R6847 VSS.t269 VSS.t261 15.0973
R6848 VSS.t161 VSS.n578 14.7102
R6849 VSS.t278 VSS.t161 14.7102
R6850 VSS.t302 VSS.t274 14.7102
R6851 VSS.n373 VSS.t302 14.7102
R6852 VSS.n524 VSS.n488 14.6013
R6853 VSS.n93 VSS.t221 14.4423
R6854 VSS.t211 VSS.n89 14.4423
R6855 VSS.n612 VSS.n288 14.0016
R6856 VSS.n708 VSS.n279 14.0016
R6857 VSS.n599 VSS.n278 14.0016
R6858 VSS.n592 VSS.n301 14.0016
R6859 VSS.n1995 VSS.n73 13.2682
R6860 VSS.n566 VSS.t5 13.1618
R6861 VSS.t259 VSS.n380 13.1618
R6862 VSS.t233 VSS.t329 12.2205
R6863 VSS.t230 VSS.n96 12.2205
R6864 VSS.n86 VSS.t202 12.2205
R6865 VSS.t326 VSS.t199 12.2205
R6866 VSS.n557 VSS.n556 12.0936
R6867 VSS.n456 VSS.n388 12.0936
R6868 VSS.n532 VSS.n531 11.8975
R6869 VSS.n555 VSS.n480 11.8141
R6870 VSS.t137 VSS.n410 11.6884
R6871 VSS.n773 VSS.t170 11.6884
R6872 VSS.n604 VSS.n602 11.2697
R6873 VSS.n771 VSS.n770 11.1684
R6874 VSS.t220 VSS.t142 10.5541
R6875 VSS.t154 VSS.t212 10.5541
R6876 VSS.t333 VSS.n99 8.88774
R6877 VSS.t331 VSS.n98 8.88774
R6878 VSS.t329 VSS.n97 8.88774
R6879 VSS.n85 VSS.t326 8.88774
R6880 VSS.n84 VSS.t324 8.88774
R6881 VSS.n83 VSS.t322 8.88774
R6882 VSS.n433 VSS.n432 8.501
R6883 VSS.n433 VSS.n421 8.501
R6884 VSS.n433 VSS.n420 8.501
R6885 VSS.n433 VSS.n419 8.501
R6886 VSS.n433 VSS.n418 8.501
R6887 VSS.n433 VSS.n417 8.501
R6888 VSS.n434 VSS.n433 8.501
R6889 VSS.n433 VSS.n395 8.501
R6890 VSS.n442 VSS.n393 8.501
R6891 VSS.n442 VSS.n394 8.501
R6892 VSS.n443 VSS.n442 8.501
R6893 VSS.n456 VSS.n383 8.501
R6894 VSS.n456 VSS.n384 8.501
R6895 VSS.n456 VSS.n385 8.501
R6896 VSS.n456 VSS.n387 8.501
R6897 VSS.n456 VSS.n327 8.501
R6898 VSS.n555 VSS.n539 8.501
R6899 VSS.n555 VSS.n540 8.501
R6900 VSS.n555 VSS.n541 8.501
R6901 VSS.n555 VSS.n542 8.501
R6902 VSS.n555 VSS.n554 8.501
R6903 VSS.n531 VSS.n495 8.501
R6904 VSS.n531 VSS.n496 8.501
R6905 VSS.n531 VSS.n497 8.501
R6906 VSS.n531 VSS.n498 8.501
R6907 VSS.n531 VSS.n499 8.501
R6908 VSS.n531 VSS.n500 8.501
R6909 VSS.n531 VSS.n494 8.501
R6910 VSS.n524 VSS.n487 8.501
R6911 VSS.n524 VSS.n518 8.501
R6912 VSS.n524 VSS.n523 8.501
R6913 VSS.n525 VSS.n524 8.501
R6914 VSS.n771 VSS.n266 8.501
R6915 VSS.n771 VSS.n267 8.501
R6916 VSS.n771 VSS.n268 8.501
R6917 VSS.n771 VSS.n269 8.501
R6918 VSS.n771 VSS.n270 8.501
R6919 VSS.n367 VSS.n331 8.501
R6920 VSS.n367 VSS.n332 8.501
R6921 VSS.n367 VSS.n333 8.501
R6922 VSS.n367 VSS.n334 8.501
R6923 VSS.n367 VSS.n335 8.501
R6924 VSS.n367 VSS.n336 8.501
R6925 VSS.n367 VSS.n337 8.501
R6926 VSS.n367 VSS.n338 8.501
R6927 VSS.n367 VSS.n339 8.501
R6928 VSS.n367 VSS.n340 8.501
R6929 VSS.n367 VSS.n341 8.501
R6930 VSS.n367 VSS.n364 8.501
R6931 VSS.n367 VSS.n366 8.501
R6932 VSS.n178 VSS.n176 8.501
R6933 VSS.n1995 VSS.n1994 8.501
R6934 VSS.n1996 VSS.n1995 8.501
R6935 VSS.n1023 VSS.n1022 8.501
R6936 VSS.n1022 VSS.n262 8.501
R6937 VSS.n1022 VSS.n261 8.501
R6938 VSS.n1022 VSS.n260 8.501
R6939 VSS.n1022 VSS.n259 8.501
R6940 VSS.n1413 VSS.n1401 8.501
R6941 VSS.n1413 VSS.n1409 8.501
R6942 VSS.n1413 VSS.n1412 8.501
R6943 VSS.n1413 VSS.n1403 8.501
R6944 VSS.n1413 VSS.n1404 8.501
R6945 VSS.n1413 VSS.n1405 8.501
R6946 VSS.n1413 VSS.n1406 8.501
R6947 VSS.n1413 VSS.n1407 8.501
R6948 VSS.n1414 VSS.n1413 8.501
R6949 VSS.n1413 VSS.n1402 8.501
R6950 VSS.n381 VSS.n322 8.5005
R6951 VSS.n380 VSS.n322 8.5005
R6952 VSS.n379 VSS.n322 8.5005
R6953 VSS.n373 VSS.n322 8.5005
R6954 VSS.n372 VSS.n322 8.5005
R6955 VSS.n371 VSS.n322 8.5005
R6956 VSS.n378 VSS.n322 8.5005
R6957 VSS.n377 VSS.n322 8.5005
R6958 VSS.n376 VSS.n322 8.5005
R6959 VSS.n375 VSS.n322 8.5005
R6960 VSS.n374 VSS.n322 8.5005
R6961 VSS.n583 VSS.n580 8.5005
R6962 VSS.n583 VSS.n579 8.5005
R6963 VSS.n583 VSS.n578 8.5005
R6964 VSS.n583 VSS.n577 8.5005
R6965 VSS.n583 VSS.n575 8.5005
R6966 VSS.n583 VSS.n574 8.5005
R6967 VSS.n583 VSS.n571 8.5005
R6968 VSS.n583 VSS.n570 8.5005
R6969 VSS.n583 VSS.n567 8.5005
R6970 VSS.n583 VSS.n566 8.5005
R6971 VSS.n583 VSS.n565 8.5005
R6972 VSS.n368 VSS.n322 8.5005
R6973 VSS.n177 VSS.n120 8.5005
R6974 VSS.n179 VSS.n120 8.5005
R6975 VSS.n1993 VSS.n1992 8.5005
R6976 VSS.n1992 VSS.n1989 8.5005
R6977 VSS.n1997 VSS.n120 8.5005
R6978 VSS.n1997 VSS.n77 8.5005
R6979 VSS.n1997 VSS.n78 8.5005
R6980 VSS.n1997 VSS.n79 8.5005
R6981 VSS.n1997 VSS.n80 8.5005
R6982 VSS.n1997 VSS.n81 8.5005
R6983 VSS.n1997 VSS.n82 8.5005
R6984 VSS.n1997 VSS.n83 8.5005
R6985 VSS.n1997 VSS.n84 8.5005
R6986 VSS.n1997 VSS.n85 8.5005
R6987 VSS.n1997 VSS.n86 8.5005
R6988 VSS.n1997 VSS.n87 8.5005
R6989 VSS.n1997 VSS.n88 8.5005
R6990 VSS.n1997 VSS.n89 8.5005
R6991 VSS.n1997 VSS.n90 8.5005
R6992 VSS.n1997 VSS.n91 8.5005
R6993 VSS.n1997 VSS.n92 8.5005
R6994 VSS.n1997 VSS.n93 8.5005
R6995 VSS.n1997 VSS.n94 8.5005
R6996 VSS.n1997 VSS.n95 8.5005
R6997 VSS.n1997 VSS.n96 8.5005
R6998 VSS.n1997 VSS.n97 8.5005
R6999 VSS.n1997 VSS.n98 8.5005
R7000 VSS.n1997 VSS.n99 8.5005
R7001 VSS.n1997 VSS.n100 8.5005
R7002 VSS.n1997 VSS.n101 8.5005
R7003 VSS.n1997 VSS.n102 8.5005
R7004 VSS.n1997 VSS.n105 8.5005
R7005 VSS.n1997 VSS.n106 8.5005
R7006 VSS.n1997 VSS.n107 8.5005
R7007 VSS.n1408 VSS.n32 8.5005
R7008 VSS.n1410 VSS.n32 8.5005
R7009 VSS.n1411 VSS.n32 8.5005
R7010 VSS.n1997 VSS.n32 8.5005
R7011 VSS.n365 VSS.n321 8.48727
R7012 VSS.n710 VSS.n709 8.48293
R7013 VSS.n709 VSS.n594 8.48293
R7014 VSS.n762 VSS.n322 8.47281
R7015 VSS.n583 VSS.n576 8.47281
R7016 VSS.n464 VSS.n322 8.47281
R7017 VSS.n583 VSS.n569 8.47281
R7018 VSS.n769 VSS.n317 8.46932
R7019 VSS.n1416 VSS.n1415 8.38237
R7020 VSS.n1423 VSS.n1394 8.36189
R7021 VSS.n1422 VSS.n1395 8.35081
R7022 VSS.n431 VSS.n430 8.31934
R7023 VSS.n429 VSS.n422 8.31934
R7024 VSS.n428 VSS.n423 8.31934
R7025 VSS.n427 VSS.n424 8.31934
R7026 VSS.n426 VSS.n425 8.31934
R7027 VSS.n404 VSS.n403 8.31934
R7028 VSS.n436 VSS.n435 8.31934
R7029 VSS.n438 VSS.n437 8.31934
R7030 VSS.n392 VSS.n391 8.31934
R7031 VSS.n445 VSS.n444 8.31934
R7032 VSS.n452 VSS.n389 8.31934
R7033 VSS.n451 VSS.n446 8.31934
R7034 VSS.n450 VSS.n447 8.31934
R7035 VSS.n449 VSS.n448 8.31934
R7036 VSS.n386 VSS.n326 8.31934
R7037 VSS.n459 VSS.n458 8.31934
R7038 VSS.n544 VSS.n543 8.31934
R7039 VSS.n546 VSS.n545 8.31934
R7040 VSS.n548 VSS.n547 8.31934
R7041 VSS.n550 VSS.n549 8.31934
R7042 VSS.n552 VSS.n551 8.31934
R7043 VSS.n553 VSS.n482 8.31934
R7044 VSS.n515 VSS.n501 8.31934
R7045 VSS.n514 VSS.n503 8.31934
R7046 VSS.n513 VSS.n504 8.31934
R7047 VSS.n512 VSS.n505 8.31934
R7048 VSS.n511 VSS.n506 8.31934
R7049 VSS.n510 VSS.n507 8.31934
R7050 VSS.n509 VSS.n508 8.31934
R7051 VSS.n520 VSS.n519 8.31934
R7052 VSS.n522 VSS.n521 8.31934
R7053 VSS.n517 VSS.n516 8.31934
R7054 VSS.n527 VSS.n526 8.31934
R7055 VSS.n308 VSS.n307 8.31934
R7056 VSS.n310 VSS.n309 8.31934
R7057 VSS.n312 VSS.n311 8.31934
R7058 VSS.n314 VSS.n313 8.31934
R7059 VSS.n316 VSS.n315 8.31934
R7060 VSS.n343 VSS.n342 8.31934
R7061 VSS.n345 VSS.n344 8.31934
R7062 VSS.n347 VSS.n346 8.31934
R7063 VSS.n349 VSS.n348 8.31934
R7064 VSS.n351 VSS.n350 8.31934
R7065 VSS.n353 VSS.n352 8.31934
R7066 VSS.n355 VSS.n354 8.31934
R7067 VSS.n357 VSS.n356 8.31934
R7068 VSS.n359 VSS.n358 8.31934
R7069 VSS.n361 VSS.n360 8.31934
R7070 VSS.n363 VSS.n362 8.31934
R7071 VSS.n1421 VSS.n1396 8.31934
R7072 VSS.n1420 VSS.n1397 8.31934
R7073 VSS.n1419 VSS.n1398 8.31934
R7074 VSS.n1418 VSS.n1399 8.31934
R7075 VSS.n1417 VSS.n1400 8.31934
R7076 VSS.n101 VSS.t244 7.77684
R7077 VSS.t232 VSS.t328 7.77684
R7078 VSS.t327 VSS.t200 7.77684
R7079 VSS.t188 VSS.n81 7.77684
R7080 VSS.n574 VSS.t0 6.96824
R7081 VSS.t264 VSS.n376 6.96824
R7082 VSS.n433 VSS.n416 6.95872
R7083 VSS.n283 VSS.t156 6.3859
R7084 VSS.n1621 VSS.t177 6.00796
R7085 VSS.n1618 VSS.t180 6.00796
R7086 VSS.n1613 VSS.t183 6.00796
R7087 VSS.n1429 VSS.t186 6.00796
R7088 VSS.n1600 VSS.t189 6.00796
R7089 VSS.n1436 VSS.t192 6.00796
R7090 VSS.n1588 VSS.t195 6.00796
R7091 VSS.n1581 VSS.t198 6.00796
R7092 VSS.n1578 VSS.t201 6.00796
R7093 VSS.n1574 VSS.t204 6.00796
R7094 VSS.n1570 VSS.t207 6.00796
R7095 VSS.n1566 VSS.t210 6.00796
R7096 VSS.n1561 VSS.t213 6.00796
R7097 VSS.n1558 VSS.t216 6.00796
R7098 VSS.n1554 VSS.t219 6.00796
R7099 VSS.n1550 VSS.t222 6.00796
R7100 VSS.n1538 VSS.t225 6.00796
R7101 VSS.n1536 VSS.t228 6.00796
R7102 VSS.n1526 VSS.t231 6.00796
R7103 VSS.n1524 VSS.t234 6.00796
R7104 VSS.n1517 VSS.t237 6.00796
R7105 VSS.n1514 VSS.t240 6.00796
R7106 VSS.n1509 VSS.t243 6.00796
R7107 VSS.n1505 VSS.t246 6.00796
R7108 VSS.n1502 VSS.t249 6.00796
R7109 VSS.n1497 VSS.t252 6.00796
R7110 VSS.n1494 VSS.t255 6.00796
R7111 VSS.n1997 VSS.n47 5.98801
R7112 VSS.n1997 VSS.n43 5.98801
R7113 VSS.n1997 VSS.n39 5.98801
R7114 VSS.n442 VSS.n390 5.66778
R7115 VSS.n555 VSS.n479 5.66778
R7116 VSS.n531 VSS.n530 5.66778
R7117 VSS.n524 VSS.n502 5.66778
R7118 VSS.n771 VSS.n271 5.66778
R7119 VSS.n176 VSS.n119 5.66778
R7120 VSS.n180 VSS.n176 5.66778
R7121 VSS.n1995 VSS.n72 5.66778
R7122 VSS.n1022 VSS.n109 5.66778
R7123 VSS.n1413 VSS.n31 5.66778
R7124 VSS.n456 VSS.n455 5.66767
R7125 VSS.n1998 VSS.n1997 5.58198
R7126 VSS.n94 VSS.t224 5.55503
R7127 VSS.t208 VSS.n88 5.55503
R7128 VSS.n442 VSS.n441 5.37299
R7129 VSS.n1997 VSS.n51 5.35273
R7130 VSS VSS.n282 5.30273
R7131 VSS.t1 VSS.t282 4.64566
R7132 VSS.t280 VSS.t163 4.64566
R7133 VSS.t300 VSS.t272 4.64566
R7134 VSS.t271 VSS.t263 4.64566
R7135 VSS.n605 VSS.t316 4.43989
R7136 VSS.n544 VSS.n476 4.33455
R7137 VSS.n439 VSS.n436 4.31766
R7138 VSS.n439 VSS.n438 4.26401
R7139 VSS.n457 VSS.n456 4.251
R7140 VSS.n709 VSS.n597 4.20628
R7141 VSS.n709 VSS.n606 4.20622
R7142 VSS.n709 VSS.n707 4.20622
R7143 VSS.n709 VSS.n613 4.20622
R7144 VSS.n343 VSS.n324 4.2061
R7145 VSS.n430 VSS.n325 4.18191
R7146 VSS.n761 VSS.n760 4.15689
R7147 VSS.n732 VSS.n467 4.15092
R7148 VSS.n520 VSS.n483 4.09011
R7149 VSS.n509 VSS.n484 4.07908
R7150 VSS.t282 VSS.n571 3.87147
R7151 VSS.n377 VSS.t271 3.87147
R7152 VSS.n561 VSS.n484 3.85858
R7153 VSS.n454 VSS.n453 3.8229
R7154 VSS.n529 VSS.n528 3.82273
R7155 VSS.n769 VSS.n289 3.75289
R7156 VSS.n769 VSS.n290 3.75289
R7157 VSS.n769 VSS.n291 3.75289
R7158 VSS.n769 VSS.n292 3.75289
R7159 VSS.n769 VSS.n293 3.75289
R7160 VSS.n769 VSS.n294 3.75289
R7161 VSS.n769 VSS.n295 3.75289
R7162 VSS.n769 VSS.n296 3.75289
R7163 VSS.n769 VSS.n300 3.75289
R7164 VSS.n769 VSS.n303 3.75289
R7165 VSS.n769 VSS.n275 3.75289
R7166 VSS.n769 VSS.n274 3.75289
R7167 VSS.n769 VSS.n305 3.75289
R7168 VSS.n769 VSS.n273 3.75289
R7169 VSS.n769 VSS.n306 3.75289
R7170 VSS.n183 VSS.n175 3.7375
R7171 VSS.n767 VSS.n277 3.71148
R7172 VSS.n568 VSS.n564 3.59151
R7173 VSS.n463 VSS.n462 3.54283
R7174 VSS.n308 VSS.n285 3.53902
R7175 VSS.n1991 VSS.n74 3.47675
R7176 VSS.n640 VSS.t311 3.46746
R7177 VSS.n104 VSS.n103 3.46536
R7178 VSS.n1991 VSS.n104 3.45299
R7179 VSS.n103 VSS.n74 3.4519
R7180 VSS.n1997 VSS.n55 3.39622
R7181 VSS.n709 VSS.n601 3.34392
R7182 VSS.n709 VSS.n589 3.34376
R7183 VSS.n709 VSS.n639 3.34368
R7184 VSS.n709 VSS.n614 3.34368
R7185 VSS.t227 VSS.n95 3.33322
R7186 VSS.n87 VSS.t205 3.33322
R7187 VSS.n284 VSS.n277 3.31562
R7188 VSS.n465 VSS.t268 3.2328
R7189 VSS.n572 VSS.t277 3.2328
R7190 VSS.n463 VSS.t270 3.23102
R7191 VSS.n568 VSS.t284 3.23102
R7192 VSS.n285 VSS.n284 3.2017
R7193 VSS.n462 VSS.n461 3.18302
R7194 VSS.t346 VSS.n616 3.15176
R7195 VSS.n637 VSS.t288 3.15176
R7196 VSS.n768 VSS.n767 3.15001
R7197 VSS.n768 VSS.n318 3.10487
R7198 VSS.n1424 VSS.n1393 3.05069
R7199 VSS.n461 VSS.n324 2.94962
R7200 VSS.n55 VSS.t129 2.93952
R7201 VSS.n562 VSS.n483 2.90595
R7202 VSS.n460 VSS.n325 2.90282
R7203 VSS.n584 VSS.n583 2.8754
R7204 VSS.n764 VSS.n322 2.8754
R7205 VSS.n1997 VSS.n1988 2.83062
R7206 VSS.n138 VSS.n137 2.7936
R7207 VSS.n1348 VSS.n1344 2.7936
R7208 VSS.n169 VSS.n168 2.79302
R7209 VSS.n1387 VSS.n1386 2.79302
R7210 VSS.n153 VSS.n126 2.79257
R7211 VSS.n159 VSS.n158 2.79257
R7212 VSS.n150 VSS.n149 2.79257
R7213 VSS.n134 VSS.n133 2.79257
R7214 VSS.n1359 VSS.n1358 2.79257
R7215 VSS.n1355 VSS.n1354 2.79257
R7216 VSS.n1371 VSS.n1370 2.79257
R7217 VSS.n1377 VSS.n1376 2.79257
R7218 VSS.n183 VSS.n182 2.76595
R7219 VSS.n1356 VSS.n1352 2.75483
R7220 VSS.n165 VSS.n164 2.75473
R7221 VSS.n129 VSS.n128 2.75473
R7222 VSS.n147 VSS.n146 2.75473
R7223 VSS.n135 VSS.n131 2.75473
R7224 VSS.n1364 VSS.n1363 2.75473
R7225 VSS.n1368 VSS.n1367 2.75473
R7226 VSS.n1347 VSS.n1346 2.75473
R7227 VSS.n1383 VSS.n1382 2.75473
R7228 VSS.n172 VSS.n171 2.75472
R7229 VSS.n143 VSS.n142 2.75466
R7230 VSS.n1390 VSS.n1389 2.7546
R7231 VSS.n585 VSS.n476 2.74712
R7232 VSS.n685 VSS.t298 2.71725
R7233 VSS.n682 VSS.t348 2.71725
R7234 VSS.n618 VSS.t345 2.71725
R7235 VSS.n622 VSS.t342 2.71725
R7236 VSS.n624 VSS.t339 2.71725
R7237 VSS.n629 VSS.t295 2.71725
R7238 VSS.n633 VSS.t292 2.71725
R7239 VSS.n635 VSS.t289 2.71725
R7240 VSS.n687 VSS.t286 2.71725
R7241 VSS.n144 VSS.n131 2.7048
R7242 VSS.n1365 VSS.n1352 2.70453
R7243 VSS.n564 VSS.n563 2.64139
R7244 VSS.n1021 VSS.n1020 2.63151
R7245 VSS.n54 VSS.t122 2.59496
R7246 VSS.n1997 VSS.n118 2.58985
R7247 VSS.n1997 VSS.n115 2.58985
R7248 VSS.n1997 VSS.n35 2.58985
R7249 VSS.n1997 VSS.n33 2.58985
R7250 VSS.n173 VSS.n172 2.57156
R7251 VSS.n166 VSS.n165 2.57141
R7252 VSS.n128 VSS.n125 2.57141
R7253 VSS.n146 VSS.n145 2.57141
R7254 VSS.n1365 VSS.n1364 2.57141
R7255 VSS.n1367 VSS.n1366 2.57141
R7256 VSS.n1346 VSS.n1343 2.57141
R7257 VSS.n1384 VSS.n1383 2.57141
R7258 VSS.n144 VSS.n143 2.57004
R7259 VSS.n1391 VSS.n1390 2.56991
R7260 VSS.n414 VSS.n328 2.45821
R7261 VSS.n412 VSS.n328 2.45821
R7262 VSS.n407 VSS.n328 2.45821
R7263 VSS.n405 VSS.n328 2.45821
R7264 VSS.n558 VSS.n538 2.45821
R7265 VSS.n538 VSS.n263 2.45821
R7266 VSS.n538 VSS.n534 2.45821
R7267 VSS.n538 VSS.n536 2.45821
R7268 VSS.t6 VSS.n565 2.32308
R7269 VSS.n381 VSS.t258 2.32308
R7270 VSS.n946 VSS.n943 2.28098
R7271 VSS.n2037 VSS.n2036 2.28098
R7272 VSS.n284 VSS.n283 2.2505
R7273 VSS.n2035 VSS.n6 2.2505
R7274 VSS.n2034 VSS.n5 2.2505
R7275 VSS.n2033 VSS.n4 2.2505
R7276 VSS.n2032 VSS.n2031 2.2505
R7277 VSS.n2030 VSS.n9 2.2505
R7278 VSS.n2022 VSS.n10 2.2505
R7279 VSS.n2024 VSS.n2023 2.2505
R7280 VSS.n2021 VSS.n14 2.2505
R7281 VSS.n2020 VSS.n2019 2.2505
R7282 VSS.n16 VSS.n15 2.2505
R7283 VSS.n2013 VSS.n2012 2.2505
R7284 VSS.n2011 VSS.n20 2.2505
R7285 VSS.n2010 VSS.n2009 2.2505
R7286 VSS.n22 VSS.n21 2.2505
R7287 VSS.n2002 VSS.n2001 2.2505
R7288 VSS.n27 VSS.n26 2.2505
R7289 VSS.n1827 VSS.n1826 2.2505
R7290 VSS.n1821 VSS.n1253 2.2505
R7291 VSS.n1254 VSS.n1252 2.2505
R7292 VSS.n1816 VSS.n1815 2.2505
R7293 VSS.n1813 VSS.n1249 2.2505
R7294 VSS.n1800 VSS.n1248 2.2505
R7295 VSS.n1805 VSS.n1247 2.2505
R7296 VSS.n1263 VSS.n1262 2.2505
R7297 VSS.n1794 VSS.n1244 2.2505
R7298 VSS.n1779 VSS.n1243 2.2505
R7299 VSS.n1784 VSS.n1242 2.2505
R7300 VSS.n1271 VSS.n1270 2.2505
R7301 VSS.n1273 VSS.n1239 2.2505
R7302 VSS.n1282 VSS.n1238 2.2505
R7303 VSS.n1279 VSS.n1237 2.2505
R7304 VSS.n1759 VSS.n1758 2.2505
R7305 VSS.n1753 VSS.n1233 2.2505
R7306 VSS.n1284 VSS.n1232 2.2505
R7307 VSS.n1736 VSS.n1231 2.2505
R7308 VSS.n1735 VSS.n1734 2.2505
R7309 VSS.n1729 VSS.n1228 2.2505
R7310 VSS.n1293 VSS.n1227 2.2505
R7311 VSS.n1303 VSS.n1226 2.2505
R7312 VSS.n1300 VSS.n1299 2.2505
R7313 VSS.n1713 VSS.n1223 2.2505
R7314 VSS.n1708 VSS.n1222 2.2505
R7315 VSS.n1305 VSS.n1221 2.2505
R7316 VSS.n1691 VSS.n1690 2.2505
R7317 VSS.n1689 VSS.n1311 2.2505
R7318 VSS.n1318 VSS.n1312 2.2505
R7319 VSS.n1683 VSS.n1682 2.2505
R7320 VSS.n1330 VSS.n1316 2.2505
R7321 VSS.n1333 VSS.n1328 2.2505
R7322 VSS.n1666 VSS.n1665 2.2505
R7323 VSS.n1653 VSS.n1332 2.2505
R7324 VSS.n1658 VSS.n1657 2.2505
R7325 VSS.n1338 VSS.n1337 2.2505
R7326 VSS.n1648 VSS.n1647 2.2505
R7327 VSS.n1339 VSS.n1214 2.2505
R7328 VSS.n1642 VSS.n1213 2.2505
R7329 VSS.n1639 VSS.n1212 2.2505
R7330 VSS.n1428 VSS.n1427 2.2505
R7331 VSS.n1632 VSS.n1209 2.2505
R7332 VSS.n1631 VSS.n1208 2.2505
R7333 VSS.n1630 VSS.n1207 2.2505
R7334 VSS.n1629 VSS.n1628 2.2505
R7335 VSS.n1627 VSS.n1203 2.2505
R7336 VSS.n1626 VSS.n1202 2.2505
R7337 VSS.n1625 VSS.n1201 2.2505
R7338 VSS.n1624 VSS.n1623 2.2505
R7339 VSS.n1622 VSS.n1198 2.2505
R7340 VSS.n1620 VSS.n1197 2.2505
R7341 VSS.n1619 VSS.n1196 2.2505
R7342 VSS.n1617 VSS.n1616 2.2505
R7343 VSS.n1615 VSS.n1193 2.2505
R7344 VSS.n1614 VSS.n1192 2.2505
R7345 VSS.n1612 VSS.n1191 2.2505
R7346 VSS.n1611 VSS.n1610 2.2505
R7347 VSS.n1609 VSS.n1431 2.2505
R7348 VSS.n1601 VSS.n1430 2.2505
R7349 VSS.n1603 VSS.n1602 2.2505
R7350 VSS.n1599 VSS.n1435 2.2505
R7351 VSS.n1598 VSS.n1597 2.2505
R7352 VSS.n1589 VSS.n1437 2.2505
R7353 VSS.n1591 VSS.n1590 2.2505
R7354 VSS.n1587 VSS.n1441 2.2505
R7355 VSS.n1586 VSS.n1585 2.2505
R7356 VSS.n1583 VSS.n1582 2.2505
R7357 VSS.n1580 VSS.n1183 2.2505
R7358 VSS.n1579 VSS.n1182 2.2505
R7359 VSS.n1577 VSS.n1181 2.2505
R7360 VSS.n1576 VSS.n1575 2.2505
R7361 VSS.n1573 VSS.n1178 2.2505
R7362 VSS.n1572 VSS.n1177 2.2505
R7363 VSS.n1571 VSS.n1176 2.2505
R7364 VSS.n1569 VSS.n1568 2.2505
R7365 VSS.n1567 VSS.n1172 2.2505
R7366 VSS.n1565 VSS.n1171 2.2505
R7367 VSS.n1564 VSS.n1170 2.2505
R7368 VSS.n1563 VSS.n1562 2.2505
R7369 VSS.n1560 VSS.n1167 2.2505
R7370 VSS.n1559 VSS.n1166 2.2505
R7371 VSS.n1557 VSS.n1165 2.2505
R7372 VSS.n1556 VSS.n1555 2.2505
R7373 VSS.n1553 VSS.n1162 2.2505
R7374 VSS.n1552 VSS.n1161 2.2505
R7375 VSS.n1551 VSS.n1160 2.2505
R7376 VSS.n1549 VSS.n1548 2.2505
R7377 VSS.n1547 VSS.n1442 2.2505
R7378 VSS.n1539 VSS.n1443 2.2505
R7379 VSS.n1541 VSS.n1540 2.2505
R7380 VSS.n1537 VSS.n1447 2.2505
R7381 VSS.n1535 VSS.n1534 2.2505
R7382 VSS.n1449 VSS.n1448 2.2505
R7383 VSS.n1528 VSS.n1527 2.2505
R7384 VSS.n1525 VSS.n1453 2.2505
R7385 VSS.n1523 VSS.n1522 2.2505
R7386 VSS.n1520 VSS.n1519 2.2505
R7387 VSS.n1518 VSS.n1154 2.2505
R7388 VSS.n1516 VSS.n1153 2.2505
R7389 VSS.n1515 VSS.n1152 2.2505
R7390 VSS.n1513 VSS.n1512 2.2505
R7391 VSS.n1511 VSS.n1149 2.2505
R7392 VSS.n1510 VSS.n1148 2.2505
R7393 VSS.n1508 VSS.n1147 2.2505
R7394 VSS.n1507 VSS.n1506 2.2505
R7395 VSS.n1504 VSS.n1143 2.2505
R7396 VSS.n1503 VSS.n1142 2.2505
R7397 VSS.n1501 VSS.n1141 2.2505
R7398 VSS.n1500 VSS.n1499 2.2505
R7399 VSS.n1498 VSS.n1138 2.2505
R7400 VSS.n1496 VSS.n1137 2.2505
R7401 VSS.n1495 VSS.n1136 2.2505
R7402 VSS.n1493 VSS.n1492 2.2505
R7403 VSS.n1491 VSS.n1133 2.2505
R7404 VSS.n1490 VSS.n1132 2.2505
R7405 VSS.n1489 VSS.n1131 2.2505
R7406 VSS.n1488 VSS.n1487 2.2505
R7407 VSS.n1486 VSS.n1454 2.2505
R7408 VSS.n1460 VSS.n1455 2.2505
R7409 VSS.n1480 VSS.n1479 2.2505
R7410 VSS.n1479 VSS.n191 2.2505
R7411 VSS.n1982 VSS.n1981 2.2505
R7412 VSS.n1108 VSS.n190 2.2505
R7413 VSS.n1113 VSS.n1112 2.2505
R7414 VSS.n1095 VSS.n206 2.2505
R7415 VSS.n1100 VSS.n205 2.2505
R7416 VSS.n214 VSS.n213 2.2505
R7417 VSS.n1089 VSS.n202 2.2505
R7418 VSS.n1074 VSS.n201 2.2505
R7419 VSS.n1079 VSS.n200 2.2505
R7420 VSS.n1072 VSS.n1071 2.2505
R7421 VSS.n1070 VSS.n224 2.2505
R7422 VSS.n1047 VSS.n223 2.2505
R7423 VSS.n1064 VSS.n1063 2.2505
R7424 VSS.n1058 VSS.n228 2.2505
R7425 VSS.n244 VSS.n243 2.2505
R7426 VSS.n1037 VSS.n1036 2.2505
R7427 VSS.n252 VSS.n242 2.2505
R7428 VSS.n1029 VSS.n1028 2.2505
R7429 VSS.n805 VSS.n249 2.2505
R7430 VSS.n922 VSS.n921 2.2505
R7431 VSS.n913 VSS.n802 2.2505
R7432 VSS.n807 VSS.n801 2.2505
R7433 VSS.n896 VSS.n800 2.2505
R7434 VSS.n814 VSS.n813 2.2505
R7435 VSS.n887 VSS.n797 2.2505
R7436 VSS.n876 VSS.n796 2.2505
R7437 VSS.n875 VSS.n795 2.2505
R7438 VSS.n829 VSS.n828 2.2505
R7439 VSS.n867 VSS.n791 2.2505
R7440 VSS.n856 VSS.n790 2.2505
R7441 VSS.n855 VSS.n789 2.2505
R7442 VSS.n843 VSS.n842 2.2505
R7443 VSS.n845 VSS.n786 2.2505
R7444 VSS.n847 VSS.n785 2.2505
R7445 VSS.n841 VSS.n784 2.2505
R7446 VSS.n839 VSS.n779 2.2505
R7447 VSS.n1018 VSS.n1017 2.2505
R7448 VSS.n778 VSS.n776 2.2505
R7449 VSS.n982 VSS.n981 2.2505
R7450 VSS.n980 VSS.n927 2.2505
R7451 VSS.n979 VSS.n978 2.2505
R7452 VSS.n929 VSS.n928 2.2505
R7453 VSS.n972 VSS.n971 2.2505
R7454 VSS.n970 VSS.n933 2.2505
R7455 VSS.n969 VSS.n968 2.2505
R7456 VSS.n935 VSS.n934 2.2505
R7457 VSS.n962 VSS.n961 2.2505
R7458 VSS.n960 VSS.n939 2.2505
R7459 VSS.n959 VSS.n958 2.2505
R7460 VSS.n941 VSS.n940 2.2505
R7461 VSS.n949 VSS.n948 2.2505
R7462 VSS.n950 VSS.n947 2.2505
R7463 VSS.n8 VSS.n7 2.2505
R7464 VSS.n2039 VSS.n6 2.2505
R7465 VSS.n2040 VSS.n5 2.2505
R7466 VSS.n2041 VSS.n4 2.2505
R7467 VSS.n2031 VSS.n3 2.2505
R7468 VSS.n2030 VSS.n2029 2.2505
R7469 VSS.n11 VSS.n10 2.2505
R7470 VSS.n2025 VSS.n2024 2.2505
R7471 VSS.n14 VSS.n13 2.2505
R7472 VSS.n2019 VSS.n2018 2.2505
R7473 VSS.n17 VSS.n16 2.2505
R7474 VSS.n2014 VSS.n2013 2.2505
R7475 VSS.n20 VSS.n19 2.2505
R7476 VSS.n2009 VSS.n2008 2.2505
R7477 VSS.n23 VSS.n22 2.2505
R7478 VSS.n2003 VSS.n2002 2.2505
R7479 VSS.n26 VSS.n25 2.2505
R7480 VSS.n1829 VSS.n1827 2.2505
R7481 VSS.n1830 VSS.n1253 2.2505
R7482 VSS.n1831 VSS.n1252 2.2505
R7483 VSS.n1815 VSS.n1250 2.2505
R7484 VSS.n1835 VSS.n1249 2.2505
R7485 VSS.n1836 VSS.n1248 2.2505
R7486 VSS.n1837 VSS.n1247 2.2505
R7487 VSS.n1262 VSS.n1245 2.2505
R7488 VSS.n1844 VSS.n1244 2.2505
R7489 VSS.n1845 VSS.n1243 2.2505
R7490 VSS.n1846 VSS.n1242 2.2505
R7491 VSS.n1270 VSS.n1240 2.2505
R7492 VSS.n1850 VSS.n1239 2.2505
R7493 VSS.n1851 VSS.n1238 2.2505
R7494 VSS.n1852 VSS.n1237 2.2505
R7495 VSS.n1758 VSS.n1234 2.2505
R7496 VSS.n1856 VSS.n1233 2.2505
R7497 VSS.n1857 VSS.n1232 2.2505
R7498 VSS.n1858 VSS.n1231 2.2505
R7499 VSS.n1734 VSS.n1229 2.2505
R7500 VSS.n1862 VSS.n1228 2.2505
R7501 VSS.n1863 VSS.n1227 2.2505
R7502 VSS.n1864 VSS.n1226 2.2505
R7503 VSS.n1299 VSS.n1224 2.2505
R7504 VSS.n1868 VSS.n1223 2.2505
R7505 VSS.n1869 VSS.n1222 2.2505
R7506 VSS.n1870 VSS.n1221 2.2505
R7507 VSS.n1690 VSS.n1220 2.2505
R7508 VSS.n1689 VSS.n1688 2.2505
R7509 VSS.n1313 VSS.n1312 2.2505
R7510 VSS.n1684 VSS.n1683 2.2505
R7511 VSS.n1316 VSS.n1315 2.2505
R7512 VSS.n1335 VSS.n1333 2.2505
R7513 VSS.n1665 VSS.n1664 2.2505
R7514 VSS.n1334 VSS.n1332 2.2505
R7515 VSS.n1659 VSS.n1658 2.2505
R7516 VSS.n1337 VSS.n1336 2.2505
R7517 VSS.n1647 VSS.n1215 2.2505
R7518 VSS.n1878 VSS.n1214 2.2505
R7519 VSS.n1879 VSS.n1213 2.2505
R7520 VSS.n1880 VSS.n1212 2.2505
R7521 VSS.n1427 VSS.n1210 2.2505
R7522 VSS.n1884 VSS.n1209 2.2505
R7523 VSS.n1885 VSS.n1208 2.2505
R7524 VSS.n1886 VSS.n1207 2.2505
R7525 VSS.n1628 VSS.n1204 2.2505
R7526 VSS.n1890 VSS.n1203 2.2505
R7527 VSS.n1891 VSS.n1202 2.2505
R7528 VSS.n1892 VSS.n1201 2.2505
R7529 VSS.n1623 VSS.n1199 2.2505
R7530 VSS.n1896 VSS.n1198 2.2505
R7531 VSS.n1897 VSS.n1197 2.2505
R7532 VSS.n1898 VSS.n1196 2.2505
R7533 VSS.n1616 VSS.n1194 2.2505
R7534 VSS.n1902 VSS.n1193 2.2505
R7535 VSS.n1903 VSS.n1192 2.2505
R7536 VSS.n1904 VSS.n1191 2.2505
R7537 VSS.n1610 VSS.n1190 2.2505
R7538 VSS.n1609 VSS.n1608 2.2505
R7539 VSS.n1432 VSS.n1430 2.2505
R7540 VSS.n1604 VSS.n1603 2.2505
R7541 VSS.n1435 VSS.n1434 2.2505
R7542 VSS.n1597 VSS.n1596 2.2505
R7543 VSS.n1438 VSS.n1437 2.2505
R7544 VSS.n1592 VSS.n1591 2.2505
R7545 VSS.n1441 VSS.n1440 2.2505
R7546 VSS.n1585 VSS.n1584 2.2505
R7547 VSS.n1583 VSS.n1184 2.2505
R7548 VSS.n1912 VSS.n1183 2.2505
R7549 VSS.n1913 VSS.n1182 2.2505
R7550 VSS.n1914 VSS.n1181 2.2505
R7551 VSS.n1575 VSS.n1179 2.2505
R7552 VSS.n1918 VSS.n1178 2.2505
R7553 VSS.n1919 VSS.n1177 2.2505
R7554 VSS.n1920 VSS.n1176 2.2505
R7555 VSS.n1568 VSS.n1173 2.2505
R7556 VSS.n1924 VSS.n1172 2.2505
R7557 VSS.n1925 VSS.n1171 2.2505
R7558 VSS.n1926 VSS.n1170 2.2505
R7559 VSS.n1562 VSS.n1168 2.2505
R7560 VSS.n1930 VSS.n1167 2.2505
R7561 VSS.n1931 VSS.n1166 2.2505
R7562 VSS.n1932 VSS.n1165 2.2505
R7563 VSS.n1555 VSS.n1163 2.2505
R7564 VSS.n1936 VSS.n1162 2.2505
R7565 VSS.n1937 VSS.n1161 2.2505
R7566 VSS.n1938 VSS.n1160 2.2505
R7567 VSS.n1548 VSS.n1159 2.2505
R7568 VSS.n1547 VSS.n1546 2.2505
R7569 VSS.n1444 VSS.n1443 2.2505
R7570 VSS.n1542 VSS.n1541 2.2505
R7571 VSS.n1447 VSS.n1446 2.2505
R7572 VSS.n1534 VSS.n1533 2.2505
R7573 VSS.n1450 VSS.n1449 2.2505
R7574 VSS.n1529 VSS.n1528 2.2505
R7575 VSS.n1453 VSS.n1452 2.2505
R7576 VSS.n1522 VSS.n1521 2.2505
R7577 VSS.n1520 VSS.n1155 2.2505
R7578 VSS.n1946 VSS.n1154 2.2505
R7579 VSS.n1947 VSS.n1153 2.2505
R7580 VSS.n1948 VSS.n1152 2.2505
R7581 VSS.n1512 VSS.n1150 2.2505
R7582 VSS.n1952 VSS.n1149 2.2505
R7583 VSS.n1953 VSS.n1148 2.2505
R7584 VSS.n1954 VSS.n1147 2.2505
R7585 VSS.n1506 VSS.n1144 2.2505
R7586 VSS.n1958 VSS.n1143 2.2505
R7587 VSS.n1959 VSS.n1142 2.2505
R7588 VSS.n1960 VSS.n1141 2.2505
R7589 VSS.n1499 VSS.n1139 2.2505
R7590 VSS.n1964 VSS.n1138 2.2505
R7591 VSS.n1965 VSS.n1137 2.2505
R7592 VSS.n1966 VSS.n1136 2.2505
R7593 VSS.n1492 VSS.n1134 2.2505
R7594 VSS.n1970 VSS.n1133 2.2505
R7595 VSS.n1971 VSS.n1132 2.2505
R7596 VSS.n1972 VSS.n1131 2.2505
R7597 VSS.n1487 VSS.n1130 2.2505
R7598 VSS.n1486 VSS.n1485 2.2505
R7599 VSS.n1456 VSS.n1455 2.2505
R7600 VSS.n1481 VSS.n1480 2.2505
R7601 VSS.n1459 VSS.n1458 2.2505
R7602 VSS.n1477 VSS.n1476 2.2505
R7603 VSS.n1465 VSS.n1464 2.2505
R7604 VSS.n1472 VSS.n1471 2.2505
R7605 VSS.n1470 VSS.n1469 2.2505
R7606 VSS.n1468 VSS.n1467 2.2505
R7607 VSS.n193 VSS.n191 2.2505
R7608 VSS.n1981 VSS.n1980 2.2505
R7609 VSS.n192 VSS.n190 2.2505
R7610 VSS.n1115 VSS.n1113 2.2505
R7611 VSS.n1116 VSS.n206 2.2505
R7612 VSS.n1117 VSS.n205 2.2505
R7613 VSS.n213 VSS.n203 2.2505
R7614 VSS.n1121 VSS.n202 2.2505
R7615 VSS.n1122 VSS.n201 2.2505
R7616 VSS.n1123 VSS.n200 2.2505
R7617 VSS.n1071 VSS.n199 2.2505
R7618 VSS.n1070 VSS.n1069 2.2505
R7619 VSS.n225 VSS.n223 2.2505
R7620 VSS.n1065 VSS.n1064 2.2505
R7621 VSS.n228 VSS.n227 2.2505
R7622 VSS.n246 VSS.n244 2.2505
R7623 VSS.n1036 VSS.n1035 2.2505
R7624 VSS.n245 VSS.n242 2.2505
R7625 VSS.n1030 VSS.n1029 2.2505
R7626 VSS.n249 VSS.n248 2.2505
R7627 VSS.n923 VSS.n922 2.2505
R7628 VSS.n992 VSS.n802 2.2505
R7629 VSS.n993 VSS.n801 2.2505
R7630 VSS.n994 VSS.n800 2.2505
R7631 VSS.n813 VSS.n798 2.2505
R7632 VSS.n998 VSS.n797 2.2505
R7633 VSS.n999 VSS.n796 2.2505
R7634 VSS.n1000 VSS.n795 2.2505
R7635 VSS.n828 VSS.n792 2.2505
R7636 VSS.n1004 VSS.n791 2.2505
R7637 VSS.n1005 VSS.n790 2.2505
R7638 VSS.n1006 VSS.n789 2.2505
R7639 VSS.n842 VSS.n787 2.2505
R7640 VSS.n1010 VSS.n786 2.2505
R7641 VSS.n1011 VSS.n785 2.2505
R7642 VSS.n1012 VSS.n784 2.2505
R7643 VSS.n781 VSS.n779 2.2505
R7644 VSS.n1017 VSS.n1016 2.2505
R7645 VSS.n780 VSS.n778 2.2505
R7646 VSS.n983 VSS.n982 2.2505
R7647 VSS.n927 VSS.n926 2.2505
R7648 VSS.n978 VSS.n977 2.2505
R7649 VSS.n930 VSS.n929 2.2505
R7650 VSS.n973 VSS.n972 2.2505
R7651 VSS.n933 VSS.n932 2.2505
R7652 VSS.n968 VSS.n967 2.2505
R7653 VSS.n936 VSS.n935 2.2505
R7654 VSS.n963 VSS.n962 2.2505
R7655 VSS.n939 VSS.n938 2.2505
R7656 VSS.n958 VSS.n957 2.2505
R7657 VSS.n955 VSS.n941 2.2505
R7658 VSS.n949 VSS.n942 2.2505
R7659 VSS.n951 VSS.n950 2.2505
R7660 VSS.n945 VSS.n944 2.2505
R7661 VSS.n2039 VSS.n2038 2.2505
R7662 VSS.n2040 VSS.n2 2.2505
R7663 VSS.n2042 VSS.n2041 2.2505
R7664 VSS.n3 VSS.n1 2.2505
R7665 VSS.n2029 VSS.n2028 2.2505
R7666 VSS.n2027 VSS.n11 2.2505
R7667 VSS.n2026 VSS.n2025 2.2505
R7668 VSS.n13 VSS.n12 2.2505
R7669 VSS.n2018 VSS.n2017 2.2505
R7670 VSS.n2016 VSS.n17 2.2505
R7671 VSS.n2015 VSS.n2014 2.2505
R7672 VSS.n19 VSS.n18 2.2505
R7673 VSS.n2008 VSS.n2007 2.2505
R7674 VSS.n2005 VSS.n23 2.2505
R7675 VSS.n2004 VSS.n2003 2.2505
R7676 VSS.n25 VSS.n24 2.2505
R7677 VSS.n1829 VSS.n1828 2.2505
R7678 VSS.n1830 VSS.n1251 2.2505
R7679 VSS.n1832 VSS.n1831 2.2505
R7680 VSS.n1833 VSS.n1250 2.2505
R7681 VSS.n1835 VSS.n1834 2.2505
R7682 VSS.n1836 VSS.n1246 2.2505
R7683 VSS.n1838 VSS.n1837 2.2505
R7684 VSS.n1842 VSS.n1245 2.2505
R7685 VSS.n1844 VSS.n1843 2.2505
R7686 VSS.n1845 VSS.n1241 2.2505
R7687 VSS.n1847 VSS.n1846 2.2505
R7688 VSS.n1848 VSS.n1240 2.2505
R7689 VSS.n1850 VSS.n1849 2.2505
R7690 VSS.n1851 VSS.n1236 2.2505
R7691 VSS.n1853 VSS.n1852 2.2505
R7692 VSS.n1854 VSS.n1234 2.2505
R7693 VSS.n1856 VSS.n1855 2.2505
R7694 VSS.n1857 VSS.n1230 2.2505
R7695 VSS.n1859 VSS.n1858 2.2505
R7696 VSS.n1860 VSS.n1229 2.2505
R7697 VSS.n1862 VSS.n1861 2.2505
R7698 VSS.n1863 VSS.n1225 2.2505
R7699 VSS.n1865 VSS.n1864 2.2505
R7700 VSS.n1866 VSS.n1224 2.2505
R7701 VSS.n1868 VSS.n1867 2.2505
R7702 VSS.n1869 VSS.n1219 2.2505
R7703 VSS.n1871 VSS.n1870 2.2505
R7704 VSS.n1220 VSS.n1218 2.2505
R7705 VSS.n1688 VSS.n1687 2.2505
R7706 VSS.n1686 VSS.n1313 2.2505
R7707 VSS.n1685 VSS.n1684 2.2505
R7708 VSS.n1315 VSS.n1314 2.2505
R7709 VSS.n1662 VSS.n1335 2.2505
R7710 VSS.n1664 VSS.n1663 2.2505
R7711 VSS.n1661 VSS.n1334 2.2505
R7712 VSS.n1660 VSS.n1659 2.2505
R7713 VSS.n1336 VSS.n1216 2.2505
R7714 VSS.n1876 VSS.n1215 2.2505
R7715 VSS.n1878 VSS.n1877 2.2505
R7716 VSS.n1879 VSS.n1211 2.2505
R7717 VSS.n1881 VSS.n1880 2.2505
R7718 VSS.n1882 VSS.n1210 2.2505
R7719 VSS.n1884 VSS.n1883 2.2505
R7720 VSS.n1885 VSS.n1206 2.2505
R7721 VSS.n1887 VSS.n1886 2.2505
R7722 VSS.n1888 VSS.n1204 2.2505
R7723 VSS.n1890 VSS.n1889 2.2505
R7724 VSS.n1891 VSS.n1200 2.2505
R7725 VSS.n1893 VSS.n1892 2.2505
R7726 VSS.n1894 VSS.n1199 2.2505
R7727 VSS.n1896 VSS.n1895 2.2505
R7728 VSS.n1897 VSS.n1195 2.2505
R7729 VSS.n1899 VSS.n1898 2.2505
R7730 VSS.n1900 VSS.n1194 2.2505
R7731 VSS.n1902 VSS.n1901 2.2505
R7732 VSS.n1903 VSS.n1189 2.2505
R7733 VSS.n1905 VSS.n1904 2.2505
R7734 VSS.n1190 VSS.n1188 2.2505
R7735 VSS.n1608 VSS.n1607 2.2505
R7736 VSS.n1606 VSS.n1432 2.2505
R7737 VSS.n1605 VSS.n1604 2.2505
R7738 VSS.n1434 VSS.n1433 2.2505
R7739 VSS.n1596 VSS.n1595 2.2505
R7740 VSS.n1594 VSS.n1438 2.2505
R7741 VSS.n1593 VSS.n1592 2.2505
R7742 VSS.n1440 VSS.n1439 2.2505
R7743 VSS.n1584 VSS.n1185 2.2505
R7744 VSS.n1910 VSS.n1184 2.2505
R7745 VSS.n1912 VSS.n1911 2.2505
R7746 VSS.n1913 VSS.n1180 2.2505
R7747 VSS.n1915 VSS.n1914 2.2505
R7748 VSS.n1916 VSS.n1179 2.2505
R7749 VSS.n1918 VSS.n1917 2.2505
R7750 VSS.n1919 VSS.n1175 2.2505
R7751 VSS.n1921 VSS.n1920 2.2505
R7752 VSS.n1922 VSS.n1173 2.2505
R7753 VSS.n1924 VSS.n1923 2.2505
R7754 VSS.n1925 VSS.n1169 2.2505
R7755 VSS.n1927 VSS.n1926 2.2505
R7756 VSS.n1928 VSS.n1168 2.2505
R7757 VSS.n1930 VSS.n1929 2.2505
R7758 VSS.n1931 VSS.n1164 2.2505
R7759 VSS.n1933 VSS.n1932 2.2505
R7760 VSS.n1934 VSS.n1163 2.2505
R7761 VSS.n1936 VSS.n1935 2.2505
R7762 VSS.n1937 VSS.n1158 2.2505
R7763 VSS.n1939 VSS.n1938 2.2505
R7764 VSS.n1159 VSS.n1157 2.2505
R7765 VSS.n1546 VSS.n1545 2.2505
R7766 VSS.n1544 VSS.n1444 2.2505
R7767 VSS.n1543 VSS.n1542 2.2505
R7768 VSS.n1446 VSS.n1445 2.2505
R7769 VSS.n1533 VSS.n1532 2.2505
R7770 VSS.n1531 VSS.n1450 2.2505
R7771 VSS.n1530 VSS.n1529 2.2505
R7772 VSS.n1452 VSS.n1451 2.2505
R7773 VSS.n1521 VSS.n1156 2.2505
R7774 VSS.n1944 VSS.n1155 2.2505
R7775 VSS.n1946 VSS.n1945 2.2505
R7776 VSS.n1947 VSS.n1151 2.2505
R7777 VSS.n1949 VSS.n1948 2.2505
R7778 VSS.n1950 VSS.n1150 2.2505
R7779 VSS.n1952 VSS.n1951 2.2505
R7780 VSS.n1953 VSS.n1146 2.2505
R7781 VSS.n1955 VSS.n1954 2.2505
R7782 VSS.n1956 VSS.n1144 2.2505
R7783 VSS.n1958 VSS.n1957 2.2505
R7784 VSS.n1959 VSS.n1140 2.2505
R7785 VSS.n1961 VSS.n1960 2.2505
R7786 VSS.n1962 VSS.n1139 2.2505
R7787 VSS.n1964 VSS.n1963 2.2505
R7788 VSS.n1965 VSS.n1135 2.2505
R7789 VSS.n1967 VSS.n1966 2.2505
R7790 VSS.n1968 VSS.n1134 2.2505
R7791 VSS.n1970 VSS.n1969 2.2505
R7792 VSS.n1971 VSS.n1129 2.2505
R7793 VSS.n1973 VSS.n1972 2.2505
R7794 VSS.n1130 VSS.n1128 2.2505
R7795 VSS.n1485 VSS.n1484 2.2505
R7796 VSS.n1483 VSS.n1456 2.2505
R7797 VSS.n1482 VSS.n1481 2.2505
R7798 VSS.n1458 VSS.n1457 2.2505
R7799 VSS.n1476 VSS.n1475 2.2505
R7800 VSS.n1474 VSS.n1465 2.2505
R7801 VSS.n1473 VSS.n1472 2.2505
R7802 VSS.n1469 VSS.n1466 2.2505
R7803 VSS.n1468 VSS.n195 2.2505
R7804 VSS.n1978 VSS.n193 2.2505
R7805 VSS.n1980 VSS.n1979 2.2505
R7806 VSS.n194 VSS.n192 2.2505
R7807 VSS.n1115 VSS.n1114 2.2505
R7808 VSS.n1116 VSS.n204 2.2505
R7809 VSS.n1118 VSS.n1117 2.2505
R7810 VSS.n1119 VSS.n203 2.2505
R7811 VSS.n1121 VSS.n1120 2.2505
R7812 VSS.n1122 VSS.n198 2.2505
R7813 VSS.n1124 VSS.n1123 2.2505
R7814 VSS.n199 VSS.n197 2.2505
R7815 VSS.n1069 VSS.n1068 2.2505
R7816 VSS.n1067 VSS.n225 2.2505
R7817 VSS.n1066 VSS.n1065 2.2505
R7818 VSS.n227 VSS.n226 2.2505
R7819 VSS.n1033 VSS.n246 2.2505
R7820 VSS.n1035 VSS.n1034 2.2505
R7821 VSS.n1032 VSS.n245 2.2505
R7822 VSS.n1031 VSS.n1030 2.2505
R7823 VSS.n248 VSS.n247 2.2505
R7824 VSS.n990 VSS.n923 2.2505
R7825 VSS.n992 VSS.n991 2.2505
R7826 VSS.n993 VSS.n799 2.2505
R7827 VSS.n995 VSS.n994 2.2505
R7828 VSS.n996 VSS.n798 2.2505
R7829 VSS.n998 VSS.n997 2.2505
R7830 VSS.n999 VSS.n794 2.2505
R7831 VSS.n1001 VSS.n1000 2.2505
R7832 VSS.n1002 VSS.n792 2.2505
R7833 VSS.n1004 VSS.n1003 2.2505
R7834 VSS.n1005 VSS.n788 2.2505
R7835 VSS.n1007 VSS.n1006 2.2505
R7836 VSS.n1008 VSS.n787 2.2505
R7837 VSS.n1010 VSS.n1009 2.2505
R7838 VSS.n1011 VSS.n783 2.2505
R7839 VSS.n1013 VSS.n1012 2.2505
R7840 VSS.n1014 VSS.n781 2.2505
R7841 VSS.n1016 VSS.n1015 2.2505
R7842 VSS.n782 VSS.n780 2.2505
R7843 VSS.n984 VSS.n983 2.2505
R7844 VSS.n926 VSS.n925 2.2505
R7845 VSS.n977 VSS.n976 2.2505
R7846 VSS.n975 VSS.n930 2.2505
R7847 VSS.n974 VSS.n973 2.2505
R7848 VSS.n932 VSS.n931 2.2505
R7849 VSS.n967 VSS.n966 2.2505
R7850 VSS.n965 VSS.n936 2.2505
R7851 VSS.n964 VSS.n963 2.2505
R7852 VSS.n938 VSS.n937 2.2505
R7853 VSS.n957 VSS.n956 2.2505
R7854 VSS.n955 VSS.n954 2.2505
R7855 VSS.n953 VSS.n942 2.2505
R7856 VSS.n952 VSS.n951 2.2505
R7857 VSS.n986 VSS.n924 2.21044
R7858 VSS.n671 VSS.n657 2.2005
R7859 VSS.n673 VSS.n672 2.2005
R7860 VSS.n674 VSS.n656 2.2005
R7861 VSS.n678 VSS.n675 2.2005
R7862 VSS.n677 VSS.n676 2.2005
R7863 VSS.n649 VSS.n648 2.2005
R7864 VSS.n695 VSS.n694 2.2005
R7865 VSS.n696 VSS.n647 2.2005
R7866 VSS.n698 VSS.n697 2.2005
R7867 VSS.n986 VSS.n985 2.2005
R7868 VSS.n987 VSS.n793 2.2005
R7869 VSS.n989 VSS.n988 2.2005
R7870 VSS.n1126 VSS.n1125 2.2005
R7871 VSS.n1977 VSS.n1976 2.2005
R7872 VSS.n1975 VSS.n1974 2.2005
R7873 VSS.n1145 VSS.n1127 2.2005
R7874 VSS.n1943 VSS.n1942 2.2005
R7875 VSS.n1941 VSS.n1940 2.2005
R7876 VSS.n1186 VSS.n1174 2.2005
R7877 VSS.n1909 VSS.n1908 2.2005
R7878 VSS.n1907 VSS.n1906 2.2005
R7879 VSS.n1205 VSS.n1187 2.2005
R7880 VSS.n1875 VSS.n1874 2.2005
R7881 VSS.n1873 VSS.n1872 2.2005
R7882 VSS.n1839 VSS.n1235 2.2005
R7883 VSS.n1841 VSS.n1840 2.2005
R7884 VSS.n2006 VSS.n0 2.2005
R7885 VSS.n2044 VSS.n2043 2.2005
R7886 VSS.n453 VSS.n445 2.14696
R7887 VSS.n528 VSS.n527 2.14652
R7888 VSS.n528 VSS.n515 2.14652
R7889 VSS.n453 VSS.n452 2.1461
R7890 VSS.n323 VSS.t273 2.12758
R7891 VSS.n477 VSS.t279 2.12758
R7892 VSS.n323 VSS.t275 2.12743
R7893 VSS.n477 VSS.t281 2.12743
R7894 VSS.n182 VSS.n120 2.07717
R7895 VSS.n154 VSS.t118 2.05104
R7896 VSS.n157 VSS.t120 2.05104
R7897 VSS.n151 VSS.t124 2.05104
R7898 VSS.n132 VSS.t126 2.05104
R7899 VSS.n136 VSS.t130 2.05104
R7900 VSS.n1357 VSS.t96 2.05104
R7901 VSS.n1353 VSS.t98 2.05104
R7902 VSS.n1372 VSS.t100 2.05104
R7903 VSS.n1375 VSS.t102 2.05104
R7904 VSS.n1349 VSS.t104 2.05104
R7905 VSS.n167 VSS.t117 2.04991
R7906 VSS.n1385 VSS.t106 2.04991
R7907 VSS.n288 VSS.t317 2.04945
R7908 VSS.n282 VSS.t319 1.97087
R7909 VSS.n80 VSS.t185 1.9703
R7910 VSS.t247 VSS.n102 1.9703
R7911 VSS.n282 VSS.t309 1.96455
R7912 VSS.n1997 VSS.n52 1.88871
R7913 VSS.n1997 VSS.n53 1.88871
R7914 VSS.n583 VSS.n480 1.73042
R7915 VSS.n1997 VSS.n30 1.69909
R7916 VSS.n585 VSS.n584 1.58288
R7917 VSS.n765 VSS.n764 1.57628
R7918 VSS.n1413 VSS.n1393 1.54884
R7919 VSS.n1022 VSS.n1021 1.54789
R7920 VSS.n584 VSS.n478 1.53487
R7921 VSS.n764 VSS.n763 1.53487
R7922 VSS.n436 VSS.n403 1.47063
R7923 VSS.n426 VSS.n403 1.47063
R7924 VSS.n427 VSS.n426 1.47063
R7925 VSS.n428 VSS.n427 1.47063
R7926 VSS.n429 VSS.n428 1.47063
R7927 VSS.n430 VSS.n429 1.47063
R7928 VSS.n438 VSS.n391 1.47063
R7929 VSS.n445 VSS.n391 1.47063
R7930 VSS.n452 VSS.n451 1.47063
R7931 VSS.n451 VSS.n450 1.47063
R7932 VSS.n450 VSS.n449 1.47063
R7933 VSS.n449 VSS.n326 1.47063
R7934 VSS.n459 VSS.n326 1.47063
R7935 VSS.n345 VSS.n343 1.47063
R7936 VSS.n347 VSS.n345 1.47063
R7937 VSS.n349 VSS.n347 1.47063
R7938 VSS.n351 VSS.n349 1.47063
R7939 VSS.n353 VSS.n351 1.47063
R7940 VSS.n355 VSS.n353 1.47063
R7941 VSS.n357 VSS.n355 1.47063
R7942 VSS.n359 VSS.n357 1.47063
R7943 VSS.n361 VSS.n359 1.47063
R7944 VSS.n362 VSS.n361 1.47063
R7945 VSS.n310 VSS.n308 1.47063
R7946 VSS.n312 VSS.n310 1.47063
R7947 VSS.n314 VSS.n312 1.47063
R7948 VSS.n316 VSS.n314 1.47063
R7949 VSS.n546 VSS.n544 1.47063
R7950 VSS.n548 VSS.n546 1.47063
R7951 VSS.n550 VSS.n548 1.47063
R7952 VSS.n551 VSS.n550 1.47063
R7953 VSS.n551 VSS.n482 1.47063
R7954 VSS.n521 VSS.n520 1.47063
R7955 VSS.n521 VSS.n516 1.47063
R7956 VSS.n527 VSS.n516 1.47063
R7957 VSS.n515 VSS.n514 1.47063
R7958 VSS.n514 VSS.n513 1.47063
R7959 VSS.n513 VSS.n512 1.47063
R7960 VSS.n512 VSS.n511 1.47063
R7961 VSS.n511 VSS.n510 1.47063
R7962 VSS.n510 VSS.n509 1.47063
R7963 VSS.n1421 VSS.n1420 1.47063
R7964 VSS.n1420 VSS.n1419 1.47063
R7965 VSS.n1419 VSS.n1418 1.47063
R7966 VSS.n1418 VSS.n1417 1.47063
R7967 VSS.n555 VSS.n481 1.41767
R7968 VSS.n1422 VSS.n1421 1.40769
R7969 VSS.n51 VSS.n29 1.40366
R7970 VSS.n1417 VSS.n1416 1.34458
R7971 VSS.n54 VSS.n51 1.34216
R7972 VSS.n1997 VSS.n73 1.24573
R7973 VSS.n163 VSS.n126 1.22642
R7974 VSS.n160 VSS.n159 1.22642
R7975 VSS.n149 VSS.n148 1.22642
R7976 VSS.n141 VSS.n134 1.22642
R7977 VSS.n139 VSS.n138 1.22642
R7978 VSS.n1360 VSS.n1359 1.22642
R7979 VSS.n1362 VSS.n1355 1.22642
R7980 VSS.n1370 VSS.n1369 1.22642
R7981 VSS.n1378 VSS.n1377 1.22642
R7982 VSS.n1381 VSS.n1344 1.22642
R7983 VSS.n170 VSS.n169 1.22603
R7984 VSS.n1388 VSS.n1387 1.22603
R7985 VSS.n154 VSS.n153 1.21785
R7986 VSS.n158 VSS.n157 1.21785
R7987 VSS.n151 VSS.n150 1.21785
R7988 VSS.n133 VSS.n132 1.21785
R7989 VSS.n142 VSS.n141 1.21785
R7990 VSS.n1358 VSS.n1357 1.21785
R7991 VSS.n1354 VSS.n1353 1.21785
R7992 VSS.n1372 VSS.n1371 1.21785
R7993 VSS.n1376 VSS.n1375 1.21785
R7994 VSS.n168 VSS.n167 1.21775
R7995 VSS.n1386 VSS.n1385 1.21775
R7996 VSS.n1389 VSS.n1388 1.21775
R7997 VSS.n164 VSS.n163 1.21706
R7998 VSS.n160 VSS.n129 1.21706
R7999 VSS.n148 VSS.n147 1.21706
R8000 VSS.n139 VSS.n135 1.21706
R8001 VSS.n137 VSS.n136 1.21706
R8002 VSS.n1360 VSS.n1356 1.21706
R8003 VSS.n1363 VSS.n1362 1.21706
R8004 VSS.n1369 VSS.n1368 1.21706
R8005 VSS.n1378 VSS.n1347 1.21706
R8006 VSS.n1382 VSS.n1381 1.21706
R8007 VSS.n1349 VSS.n1348 1.21706
R8008 VSS.n171 VSS.n170 1.21683
R8009 VSS.n317 VSS.n316 1.17067
R8010 VSS.n952 VSS.n943 1.15554
R8011 VSS.n2038 VSS.n2037 1.15554
R8012 VSS.n1423 VSS.n1422 1.14581
R8013 VSS.n362 VSS.n321 1.13477
R8014 VSS.n1675 VSS.n1327 1.13286
R8015 VSS.n1811 VSS.n1810 1.13286
R8016 VSS.n861 VSS.n833 1.13286
R8017 VSS.n1106 VSS.n1105 1.13286
R8018 VSS.n947 VSS.n946 1.13186
R8019 VSS.n2036 VSS.n2035 1.13186
R8020 VSS.n1676 VSS.n1326 1.1255
R8021 VSS.n1679 VSS.n1678 1.1255
R8022 VSS.n1677 VSS.n1309 1.1255
R8023 VSS.n1699 VSS.n1308 1.1255
R8024 VSS.n1701 VSS.n1700 1.1255
R8025 VSS.n1702 VSS.n1307 1.1255
R8026 VSS.n1704 VSS.n1703 1.1255
R8027 VSS.n1297 VSS.n1296 1.1255
R8028 VSS.n1722 VSS.n1721 1.1255
R8029 VSS.n1723 VSS.n1295 1.1255
R8030 VSS.n1726 VSS.n1725 1.1255
R8031 VSS.n1724 VSS.n1288 1.1255
R8032 VSS.n1744 VSS.n1289 1.1255
R8033 VSS.n1746 VSS.n1745 1.1255
R8034 VSS.n1747 VSS.n1286 1.1255
R8035 VSS.n1749 VSS.n1748 1.1255
R8036 VSS.n1277 VSS.n1276 1.1255
R8037 VSS.n1768 VSS.n1767 1.1255
R8038 VSS.n1769 VSS.n1275 1.1255
R8039 VSS.n1771 VSS.n1770 1.1255
R8040 VSS.n1268 VSS.n1267 1.1255
R8041 VSS.n1788 VSS.n1787 1.1255
R8042 VSS.n1789 VSS.n1266 1.1255
R8043 VSS.n1791 VSS.n1790 1.1255
R8044 VSS.n1260 VSS.n1259 1.1255
R8045 VSS.n1809 VSS.n1808 1.1255
R8046 VSS.n1674 VSS.n1673 1.1255
R8047 VSS.n1326 VSS.n1325 1.1255
R8048 VSS.n1680 VSS.n1679 1.1255
R8049 VSS.n1310 VSS.n1309 1.1255
R8050 VSS.n1699 VSS.n1698 1.1255
R8051 VSS.n1700 VSS.n1306 1.1255
R8052 VSS.n1706 VSS.n1307 1.1255
R8053 VSS.n1705 VSS.n1704 1.1255
R8054 VSS.n1298 VSS.n1297 1.1255
R8055 VSS.n1721 VSS.n1720 1.1255
R8056 VSS.n1295 VSS.n1294 1.1255
R8057 VSS.n1727 VSS.n1726 1.1255
R8058 VSS.n1290 VSS.n1288 1.1255
R8059 VSS.n1744 VSS.n1743 1.1255
R8060 VSS.n1745 VSS.n1285 1.1255
R8061 VSS.n1751 VSS.n1286 1.1255
R8062 VSS.n1750 VSS.n1749 1.1255
R8063 VSS.n1278 VSS.n1277 1.1255
R8064 VSS.n1767 VSS.n1766 1.1255
R8065 VSS.n1275 VSS.n1274 1.1255
R8066 VSS.n1772 VSS.n1771 1.1255
R8067 VSS.n1269 VSS.n1268 1.1255
R8068 VSS.n1787 VSS.n1786 1.1255
R8069 VSS.n1266 VSS.n1265 1.1255
R8070 VSS.n1792 VSS.n1791 1.1255
R8071 VSS.n1261 VSS.n1260 1.1255
R8072 VSS.n1808 VSS.n1807 1.1255
R8073 VSS.n1258 VSS.n1257 1.1255
R8074 VSS.n862 VSS.n832 1.1255
R8075 VSS.n864 VSS.n863 1.1255
R8076 VSS.n822 VSS.n821 1.1255
R8077 VSS.n881 VSS.n880 1.1255
R8078 VSS.n882 VSS.n820 1.1255
R8079 VSS.n884 VSS.n883 1.1255
R8080 VSS.n811 VSS.n810 1.1255
R8081 VSS.n899 VSS.n898 1.1255
R8082 VSS.n900 VSS.n809 1.1255
R8083 VSS.n911 VSS.n901 1.1255
R8084 VSS.n910 VSS.n902 1.1255
R8085 VSS.n909 VSS.n903 1.1255
R8086 VSS.n907 VSS.n906 1.1255
R8087 VSS.n904 VSS.n238 1.1255
R8088 VSS.n1039 VSS.n237 1.1255
R8089 VSS.n1041 VSS.n1040 1.1255
R8090 VSS.n1042 VSS.n234 1.1255
R8091 VSS.n1043 VSS.n235 1.1255
R8092 VSS.n1044 VSS.n236 1.1255
R8093 VSS.n1046 VSS.n1045 1.1255
R8094 VSS.n220 VSS.n219 1.1255
R8095 VSS.n1083 VSS.n1082 1.1255
R8096 VSS.n1084 VSS.n218 1.1255
R8097 VSS.n1086 VSS.n1085 1.1255
R8098 VSS.n211 VSS.n210 1.1255
R8099 VSS.n1104 VSS.n1103 1.1255
R8100 VSS.n860 VSS.n859 1.1255
R8101 VSS.n832 VSS.n831 1.1255
R8102 VSS.n865 VSS.n864 1.1255
R8103 VSS.n823 VSS.n822 1.1255
R8104 VSS.n880 VSS.n879 1.1255
R8105 VSS.n820 VSS.n819 1.1255
R8106 VSS.n885 VSS.n884 1.1255
R8107 VSS.n812 VSS.n811 1.1255
R8108 VSS.n898 VSS.n897 1.1255
R8109 VSS.n809 VSS.n808 1.1255
R8110 VSS.n912 VSS.n911 1.1255
R8111 VSS.n910 VSS.n804 1.1255
R8112 VSS.n909 VSS.n908 1.1255
R8113 VSS.n907 VSS.n251 1.1255
R8114 VSS.n239 VSS.n238 1.1255
R8115 VSS.n1039 VSS.n1038 1.1255
R8116 VSS.n1040 VSS.n233 1.1255
R8117 VSS.n1056 VSS.n234 1.1255
R8118 VSS.n1055 VSS.n235 1.1255
R8119 VSS.n1054 VSS.n236 1.1255
R8120 VSS.n1053 VSS.n1046 1.1255
R8121 VSS.n221 VSS.n220 1.1255
R8122 VSS.n1082 VSS.n1081 1.1255
R8123 VSS.n218 VSS.n217 1.1255
R8124 VSS.n1087 VSS.n1086 1.1255
R8125 VSS.n212 VSS.n211 1.1255
R8126 VSS.n1103 VSS.n1102 1.1255
R8127 VSS.n209 VSS.n208 1.1255
R8128 VSS.n834 VSS.n833 1.1255
R8129 VSS.n859 VSS.n858 1.1255
R8130 VSS.n831 VSS.n827 1.1255
R8131 VSS.n866 VSS.n865 1.1255
R8132 VSS.n824 VSS.n823 1.1255
R8133 VSS.n879 VSS.n878 1.1255
R8134 VSS.n819 VSS.n817 1.1255
R8135 VSS.n886 VSS.n885 1.1255
R8136 VSS.n814 VSS.n812 1.1255
R8137 VSS.n897 VSS.n896 1.1255
R8138 VSS.n808 VSS.n807 1.1255
R8139 VSS.n913 VSS.n912 1.1255
R8140 VSS.n921 VSS.n804 1.1255
R8141 VSS.n908 VSS.n805 1.1255
R8142 VSS.n1028 VSS.n251 1.1255
R8143 VSS.n252 VSS.n239 1.1255
R8144 VSS.n1038 VSS.n1037 1.1255
R8145 VSS.n243 VSS.n233 1.1255
R8146 VSS.n1057 VSS.n1056 1.1255
R8147 VSS.n1055 VSS.n229 1.1255
R8148 VSS.n1054 VSS.n230 1.1255
R8149 VSS.n1053 VSS.n1052 1.1255
R8150 VSS.n222 VSS.n221 1.1255
R8151 VSS.n1081 VSS.n1080 1.1255
R8152 VSS.n1075 VSS.n217 1.1255
R8153 VSS.n1088 VSS.n1087 1.1255
R8154 VSS.n1090 VSS.n212 1.1255
R8155 VSS.n1102 VSS.n1101 1.1255
R8156 VSS.n1096 VSS.n208 1.1255
R8157 VSS.n1107 VSS.n1106 1.1255
R8158 VSS.n1667 VSS.n1327 1.1255
R8159 VSS.n1673 VSS.n1672 1.1255
R8160 VSS.n1329 VSS.n1325 1.1255
R8161 VSS.n1681 VSS.n1680 1.1255
R8162 VSS.n1320 VSS.n1310 1.1255
R8163 VSS.n1698 VSS.n1697 1.1255
R8164 VSS.n1692 VSS.n1306 1.1255
R8165 VSS.n1707 VSS.n1706 1.1255
R8166 VSS.n1705 VSS.n1304 1.1255
R8167 VSS.n1714 VSS.n1298 1.1255
R8168 VSS.n1720 VSS.n1719 1.1255
R8169 VSS.n1302 VSS.n1294 1.1255
R8170 VSS.n1728 VSS.n1727 1.1255
R8171 VSS.n1291 VSS.n1290 1.1255
R8172 VSS.n1743 VSS.n1742 1.1255
R8173 VSS.n1737 VSS.n1285 1.1255
R8174 VSS.n1752 VSS.n1751 1.1255
R8175 VSS.n1750 VSS.n1283 1.1255
R8176 VSS.n1760 VSS.n1278 1.1255
R8177 VSS.n1766 VSS.n1765 1.1255
R8178 VSS.n1281 VSS.n1274 1.1255
R8179 VSS.n1773 VSS.n1772 1.1255
R8180 VSS.n1774 VSS.n1269 1.1255
R8181 VSS.n1786 VSS.n1785 1.1255
R8182 VSS.n1780 VSS.n1265 1.1255
R8183 VSS.n1793 VSS.n1792 1.1255
R8184 VSS.n1795 VSS.n1261 1.1255
R8185 VSS.n1807 VSS.n1806 1.1255
R8186 VSS.n1801 VSS.n1257 1.1255
R8187 VSS.n1812 VSS.n1811 1.1255
R8188 VSS.n1479 VSS.n1463 1.11866
R8189 VSS.n1479 VSS.n1462 1.11866
R8190 VSS.n1479 VSS.n1478 1.1179
R8191 VSS.n711 VSS.n710 1.03987
R8192 VSS.n661 VSS.n657 1.01835
R8193 VSS.n556 VSS.n485 1.00096
R8194 VSS.n440 VSS.n400 0.992596
R8195 VSS.n440 VSS.n398 0.992596
R8196 VSS.n440 VSS.n396 0.992596
R8197 VSS.n560 VSS.n264 0.992596
R8198 VSS.n560 VSS.n491 0.992596
R8199 VSS.n560 VSS.n489 0.992596
R8200 VSS.n140 VSS.n139 0.967195
R8201 VSS.n136 VSS.n130 0.967195
R8202 VSS.n1361 VSS.n1360 0.967195
R8203 VSS.n1357 VSS.n1351 0.967195
R8204 VSS.n55 VSS.n54 0.933565
R8205 VSS.n148 VSS.n127 0.9005
R8206 VSS.n161 VSS.n160 0.9005
R8207 VSS.n163 VSS.n162 0.9005
R8208 VSS.n170 VSS.n124 0.9005
R8209 VSS.n141 VSS.n140 0.9005
R8210 VSS.n132 VSS.n130 0.9005
R8211 VSS.n152 VSS.n151 0.9005
R8212 VSS.n157 VSS.n156 0.9005
R8213 VSS.n155 VSS.n154 0.9005
R8214 VSS.n167 VSS.n123 0.9005
R8215 VSS.n1379 VSS.n1378 0.9005
R8216 VSS.n1369 VSS.n1345 0.9005
R8217 VSS.n1362 VSS.n1361 0.9005
R8218 VSS.n1381 VSS.n1380 0.9005
R8219 VSS.n1350 VSS.n1349 0.9005
R8220 VSS.n1375 VSS.n1374 0.9005
R8221 VSS.n1373 VSS.n1372 0.9005
R8222 VSS.n1353 VSS.n1351 0.9005
R8223 VSS.n1385 VSS.n1341 0.9005
R8224 VSS.n1388 VSS.n1342 0.9005
R8225 VSS.n172 VSS.t62 0.863272
R8226 VSS.n165 VSS.t64 0.863084
R8227 VSS.n128 VSS.t66 0.863084
R8228 VSS.n146 VSS.t68 0.863084
R8229 VSS.n131 VSS.t72 0.863084
R8230 VSS.n1364 VSS.t15 0.863084
R8231 VSS.n1367 VSS.t18 0.863084
R8232 VSS.n1346 VSS.t21 0.863084
R8233 VSS.n1383 VSS.t24 0.863084
R8234 VSS.n1352 VSS.t12 0.863023
R8235 VSS.n1390 VSS.t27 0.862522
R8236 VSS.n143 VSS.t70 0.862486
R8237 VSS.n1424 VSS.n1423 0.844942
R8238 VSS.n171 VSS.t74 0.82652
R8239 VSS.n164 VSS.t75 0.826303
R8240 VSS.n129 VSS.t77 0.826303
R8241 VSS.n147 VSS.t10 0.826303
R8242 VSS.n135 VSS.t82 0.826303
R8243 VSS.n137 VSS.t115 0.826303
R8244 VSS.n1356 VSS.t28 0.826303
R8245 VSS.n1363 VSS.t30 0.826303
R8246 VSS.n1368 VSS.t32 0.826303
R8247 VSS.n1347 VSS.t34 0.826303
R8248 VSS.n1382 VSS.t36 0.826303
R8249 VSS.n1348 VSS.t58 0.826303
R8250 VSS.n168 VSS.t95 0.825755
R8251 VSS.n1386 VSS.t60 0.825755
R8252 VSS.n1389 VSS.t38 0.825755
R8253 VSS.n153 VSS.t107 0.82575
R8254 VSS.n158 VSS.t109 0.82575
R8255 VSS.n150 VSS.t111 0.82575
R8256 VSS.n133 VSS.t113 0.82575
R8257 VSS.n142 VSS.t80 0.82575
R8258 VSS.n1358 VSS.t50 0.82575
R8259 VSS.n1354 VSS.t52 0.82575
R8260 VSS.n1371 VSS.t54 0.82575
R8261 VSS.n1376 VSS.t56 0.82575
R8262 VSS.n169 VSS.t84 0.825575
R8263 VSS.n1387 VSS.t49 0.825575
R8264 VSS.n126 VSS.t85 0.8254
R8265 VSS.n159 VSS.t87 0.8254
R8266 VSS.n149 VSS.t89 0.8254
R8267 VSS.n134 VSS.t91 0.8254
R8268 VSS.n138 VSS.t93 0.8254
R8269 VSS.n1359 VSS.t39 0.8254
R8270 VSS.n1355 VSS.t41 0.8254
R8271 VSS.n1370 VSS.t43 0.8254
R8272 VSS.n1377 VSS.t45 0.8254
R8273 VSS.n1344 VSS.t47 0.8254
R8274 VSS.n766 VSS.n765 0.822942
R8275 VSS.n594 VSS.n319 0.82287
R8276 VSS.n579 VSS.t160 0.774694
R8277 VSS.t303 VSS.n372 0.774694
R8278 VSS.n662 VSS.n661 0.752675
R8279 VSS.n563 VSS.n482 0.735566
R8280 VSS.n662 VSS.n659 0.700172
R8281 VSS.n670 VSS.n659 0.700172
R8282 VSS.n670 VSS.n655 0.700172
R8283 VSS.n680 VSS.n655 0.700172
R8284 VSS.n680 VSS.n679 0.700172
R8285 VSS.n679 VSS.n650 0.700172
R8286 VSS.n692 VSS.n650 0.700172
R8287 VSS.n693 VSS.n692 0.700172
R8288 VSS.n693 VSS.n646 0.700172
R8289 VSS.n699 VSS.n646 0.700172
R8290 VSS.n663 VSS.n660 0.700172
R8291 VSS.n669 VSS.n660 0.700172
R8292 VSS.n669 VSS.n654 0.700172
R8293 VSS.n681 VSS.n654 0.700172
R8294 VSS.n681 VSS.n651 0.700172
R8295 VSS.n690 VSS.n651 0.700172
R8296 VSS.n691 VSS.n690 0.700172
R8297 VSS.n691 VSS.n644 0.700172
R8298 VSS.n645 VSS.n644 0.700172
R8299 VSS.n700 VSS.n645 0.700172
R8300 VSS.n666 VSS.n664 0.700172
R8301 VSS.n668 VSS.n666 0.700172
R8302 VSS.n668 VSS.n653 0.700172
R8303 VSS.n684 VSS.n653 0.700172
R8304 VSS.n686 VSS.n684 0.700172
R8305 VSS.n689 VSS.n686 0.700172
R8306 VSS.n689 VSS.n643 0.700172
R8307 VSS.n705 VSS.n643 0.700172
R8308 VSS.n705 VSS.n704 0.700172
R8309 VSS.n704 VSS.n702 0.700172
R8310 VSS.n671 VSS.n658 0.688887
R8311 VSS.n672 VSS.n671 0.688887
R8312 VSS.n672 VSS.n656 0.688887
R8313 VSS.n678 VSS.n656 0.688887
R8314 VSS.n678 VSS.n677 0.688887
R8315 VSS.n677 VSS.n649 0.688887
R8316 VSS.n694 VSS.n649 0.688887
R8317 VSS.n694 VSS.n647 0.688887
R8318 VSS.n698 VSS.n647 0.688887
R8319 VSS.n304 VSS.t310 0.683482
R8320 VSS.n176 VSS.n175 0.656768
R8321 VSS.n408 VSS.n258 0.648972
R8322 VSS.n460 VSS.n459 0.642753
R8323 VSS.n283 VSS 0.608854
R8324 VSS.n1676 VSS.n1675 0.568199
R8325 VSS.n1810 VSS.n1809 0.568199
R8326 VSS.n862 VSS.n861 0.568199
R8327 VSS.n1105 VSS.n1104 0.568199
R8328 VSS.n586 VSS.n585 0.55999
R8329 VSS.n461 VSS.n460 0.489389
R8330 VSS.n563 VSS.n562 0.489389
R8331 VSS.n699 VSS.n698 0.4505
R8332 VSS.n647 VSS.n646 0.4505
R8333 VSS.n694 VSS.n693 0.4505
R8334 VSS.n692 VSS.n649 0.4505
R8335 VSS.n677 VSS.n650 0.4505
R8336 VSS.n679 VSS.n678 0.4505
R8337 VSS.n680 VSS.n656 0.4505
R8338 VSS.n672 VSS.n655 0.4505
R8339 VSS.n671 VSS.n670 0.4505
R8340 VSS.n659 VSS.n658 0.4505
R8341 VSS.n700 VSS.n699 0.4505
R8342 VSS.n646 VSS.n645 0.4505
R8343 VSS.n693 VSS.n644 0.4505
R8344 VSS.n692 VSS.n691 0.4505
R8345 VSS.n690 VSS.n650 0.4505
R8346 VSS.n679 VSS.n651 0.4505
R8347 VSS.n681 VSS.n680 0.4505
R8348 VSS.n655 VSS.n654 0.4505
R8349 VSS.n670 VSS.n669 0.4505
R8350 VSS.n660 VSS.n659 0.4505
R8351 VSS.n663 VSS.n662 0.4505
R8352 VSS.n702 VSS.n700 0.4505
R8353 VSS.n704 VSS.n645 0.4505
R8354 VSS.n705 VSS.n644 0.4505
R8355 VSS.n691 VSS.n643 0.4505
R8356 VSS.n690 VSS.n689 0.4505
R8357 VSS.n686 VSS.n651 0.4505
R8358 VSS.n684 VSS.n681 0.4505
R8359 VSS.n654 VSS.n653 0.4505
R8360 VSS.n669 VSS.n668 0.4505
R8361 VSS.n666 VSS.n660 0.4505
R8362 VSS.n664 VSS.n663 0.4505
R8363 VSS.n666 VSS.n665 0.4505
R8364 VSS.n668 VSS.n667 0.4505
R8365 VSS.n653 VSS.n652 0.4505
R8366 VSS.n684 VSS.n683 0.4505
R8367 VSS.n664 VSS.n587 0.4505
R8368 VSS.n686 VSS.n685 0.4505
R8369 VSS.n689 VSS.n688 0.4505
R8370 VSS.n643 VSS.n642 0.4505
R8371 VSS.n706 VSS.n705 0.4505
R8372 VSS.n704 VSS.n703 0.4505
R8373 VSS.n702 VSS.n701 0.4505
R8374 VSS.n184 VSS.n183 0.4505
R8375 VSS.n1987 VSS.n1986 0.4505
R8376 VSS.n1986 VSS.n1985 0.4505
R8377 VSS.n1984 VSS.n1983 0.4505
R8378 VSS.n1109 VSS.n189 0.4505
R8379 VSS.n1111 VSS.n1110 0.4505
R8380 VSS.n1097 VSS.n207 0.4505
R8381 VSS.n1099 VSS.n1098 0.4505
R8382 VSS.n1094 VSS.n1093 0.4505
R8383 VSS.n1092 VSS.n1091 0.4505
R8384 VSS.n216 VSS.n215 0.4505
R8385 VSS.n1078 VSS.n1077 0.4505
R8386 VSS.n1076 VSS.n1073 0.4505
R8387 VSS.n1049 VSS.n1048 0.4505
R8388 VSS.n1051 VSS.n1050 0.4505
R8389 VSS.n1062 VSS.n1061 0.4505
R8390 VSS.n1060 VSS.n1059 0.4505
R8391 VSS.n254 VSS.n232 0.4505
R8392 VSS.n255 VSS.n241 0.4505
R8393 VSS.n256 VSS.n240 0.4505
R8394 VSS.n1027 VSS.n1026 0.4505
R8395 VSS.n253 VSS.n250 0.4505
R8396 VSS.n920 VSS.n919 0.4505
R8397 VSS.n917 VSS.n803 0.4505
R8398 VSS.n915 VSS.n914 0.4505
R8399 VSS.n895 VSS.n806 0.4505
R8400 VSS.n894 VSS.n893 0.4505
R8401 VSS.n818 VSS.n815 0.4505
R8402 VSS.n889 VSS.n888 0.4505
R8403 VSS.n877 VSS.n816 0.4505
R8404 VSS.n874 VSS.n873 0.4505
R8405 VSS.n830 VSS.n825 0.4505
R8406 VSS.n869 VSS.n868 0.4505
R8407 VSS.n857 VSS.n826 0.4505
R8408 VSS.n854 VSS.n853 0.4505
R8409 VSS.n844 VSS.n835 0.4505
R8410 VSS.n846 VSS.n838 0.4505
R8411 VSS.n849 VSS.n848 0.4505
R8412 VSS.n840 VSS.n837 0.4505
R8413 VSS.n836 VSS.n777 0.4505
R8414 VSS.n1020 VSS.n1019 0.4505
R8415 VSS.n1425 VSS.n1424 0.4505
R8416 VSS.n1644 VSS.n1643 0.4505
R8417 VSS.n1646 VSS.n1645 0.4505
R8418 VSS.n1650 VSS.n1649 0.4505
R8419 VSS.n1652 VSS.n1651 0.4505
R8420 VSS.n1656 VSS.n1655 0.4505
R8421 VSS.n1654 VSS.n1331 0.4505
R8422 VSS.n1669 VSS.n1668 0.4505
R8423 VSS.n1671 VSS.n1670 0.4505
R8424 VSS.n1319 VSS.n1317 0.4505
R8425 VSS.n1324 VSS.n1323 0.4505
R8426 VSS.n1322 VSS.n1321 0.4505
R8427 VSS.n1696 VSS.n1695 0.4505
R8428 VSS.n1694 VSS.n1693 0.4505
R8429 VSS.n1710 VSS.n1709 0.4505
R8430 VSS.n1712 VSS.n1711 0.4505
R8431 VSS.n1716 VSS.n1715 0.4505
R8432 VSS.n1718 VSS.n1717 0.4505
R8433 VSS.n1301 VSS.n1292 0.4505
R8434 VSS.n1731 VSS.n1730 0.4505
R8435 VSS.n1733 VSS.n1732 0.4505
R8436 VSS.n1741 VSS.n1740 0.4505
R8437 VSS.n1739 VSS.n1738 0.4505
R8438 VSS.n1755 VSS.n1754 0.4505
R8439 VSS.n1757 VSS.n1756 0.4505
R8440 VSS.n1762 VSS.n1761 0.4505
R8441 VSS.n1764 VSS.n1763 0.4505
R8442 VSS.n1280 VSS.n1272 0.4505
R8443 VSS.n1776 VSS.n1775 0.4505
R8444 VSS.n1778 VSS.n1777 0.4505
R8445 VSS.n1783 VSS.n1782 0.4505
R8446 VSS.n1781 VSS.n1264 0.4505
R8447 VSS.n1797 VSS.n1796 0.4505
R8448 VSS.n1799 VSS.n1798 0.4505
R8449 VSS.n1804 VSS.n1803 0.4505
R8450 VSS.n1802 VSS.n1256 0.4505
R8451 VSS.n1814 VSS.n1255 0.4505
R8452 VSS.n1818 VSS.n1817 0.4505
R8453 VSS.n1820 VSS.n1819 0.4505
R8454 VSS.n1823 VSS.n1822 0.4505
R8455 VSS.n1825 VSS.n1824 0.4505
R8456 VSS.n2000 VSS.n1999 0.4505
R8457 VSS.n1634 VSS.n1633 0.4505
R8458 VSS.n1636 VSS.n1635 0.4505
R8459 VSS.n1638 VSS.n1637 0.4505
R8460 VSS.n1641 VSS.n1340 0.4505
R8461 VSS.n1997 VSS.n122 0.404677
R8462 VSS.n1997 VSS.n71 0.404677
R8463 VSS.n562 VSS.n561 0.37175
R8464 VSS.n415 VSS.n328 0.36382
R8465 VSS.n413 VSS.n328 0.36382
R8466 VSS.n411 VSS.n328 0.36382
R8467 VSS.n406 VSS.n328 0.36382
R8468 VSS.n538 VSS.n493 0.36382
R8469 VSS.n538 VSS.n535 0.36382
R8470 VSS.n538 VSS.n533 0.36382
R8471 VSS.n538 VSS.n537 0.36382
R8472 VSS.n753 VSS.n752 0.363088
R8473 VSS.n725 VSS.n720 0.363088
R8474 VSS.n745 VSS.n744 0.363083
R8475 VSS.n752 VSS.n735 0.363083
R8476 VSS.n714 VSS.n713 0.363083
R8477 VSS.n721 VSS.n720 0.363083
R8478 VSS.n758 VSS.n757 0.3605
R8479 VSS.n759 VSS.n734 0.3605
R8480 VSS.n747 VSS.n733 0.3605
R8481 VSS.n738 VSS.n736 0.3605
R8482 VSS.n757 VSS.n756 0.3605
R8483 VSS.n737 VSS.n734 0.3605
R8484 VSS.n748 VSS.n747 0.3605
R8485 VSS.n746 VSS.n742 0.3605
R8486 VSS.n740 VSS.n738 0.3605
R8487 VSS.n756 VSS.n755 0.3605
R8488 VSS.n739 VSS.n737 0.3605
R8489 VSS.n749 VSS.n748 0.3605
R8490 VSS.n742 VSS.n741 0.3605
R8491 VSS.n744 VSS.n743 0.3605
R8492 VSS.n750 VSS.n749 0.3605
R8493 VSS.n751 VSS.n739 0.3605
R8494 VSS.n755 VSS.n754 0.3605
R8495 VSS.n743 VSS.n319 0.3605
R8496 VSS.n741 VSS.n320 0.3605
R8497 VSS.n471 VSS.n469 0.3605
R8498 VSS.n731 VSS.n730 0.3605
R8499 VSS.n470 VSS.n468 0.3605
R8500 VSS.n723 VSS.n722 0.3605
R8501 VSS.n473 VSS.n471 0.3605
R8502 VSS.n730 VSS.n729 0.3605
R8503 VSS.n472 VSS.n470 0.3605
R8504 VSS.n716 VSS.n715 0.3605
R8505 VSS.n724 VSS.n723 0.3605
R8506 VSS.n475 VSS.n473 0.3605
R8507 VSS.n729 VSS.n728 0.3605
R8508 VSS.n474 VSS.n472 0.3605
R8509 VSS.n717 VSS.n716 0.3605
R8510 VSS.n713 VSS.n712 0.3605
R8511 VSS.n719 VSS.n474 0.3605
R8512 VSS.n728 VSS.n727 0.3605
R8513 VSS.n726 VSS.n475 0.3605
R8514 VSS.n712 VSS.n711 0.3605
R8515 VSS.n718 VSS.n717 0.3605
R8516 VSS.t266 VSS.n272 0.341991
R8517 VSS.n769 VSS.n285 0.336222
R8518 VSS.n462 VSS.n322 0.315774
R8519 VSS.n440 VSS.n402 0.313215
R8520 VSS.n1998 VSS.n29 0.306109
R8521 VSS.n560 VSS.n486 0.296878
R8522 VSS.n661 VSS.n658 0.295548
R8523 VSS.t9 VSS.n408 0.281056
R8524 VSS.n763 VSS.n323 0.272937
R8525 VSS.n478 VSS.n477 0.272937
R8526 VSS.n583 VSS.n564 0.261962
R8527 VSS.n586 VSS.n318 0.259755
R8528 VSS.n767 VSS.n766 0.258872
R8529 VSS.n1986 VSS.n185 0.2546
R8530 VSS.n1416 VSS.n32 0.238267
R8531 VSS.n1986 VSS.n187 0.224483
R8532 VSS.n174 VSS.n173 0.214913
R8533 VSS.n1392 VSS.n1391 0.214913
R8534 VSS.n1997 VSS.n50 0.213286
R8535 VSS.n185 VSS.n184 0.21148
R8536 VSS.n1426 VSS.n1425 0.21148
R8537 VSS.n754 VSS.n753 0.186469
R8538 VSS.n726 VSS.n725 0.186469
R8539 VSS.n745 VSS.n733 0.184224
R8540 VSS.n758 VSS.n735 0.184224
R8541 VSS.n714 VSS.n468 0.184224
R8542 VSS.n721 VSS.n469 0.184224
R8543 VSS.n652 VSS.n614 0.18071
R8544 VSS.n642 VSS.n639 0.18071
R8545 VSS.n667 VSS.n613 0.180438
R8546 VSS.n707 VSS.n706 0.180181
R8547 VSS.n1997 VSS.n76 0.179709
R8548 VSS.n703 VSS.n589 0.179574
R8549 VSS.n665 VSS.n601 0.17957
R8550 VSS.n701 VSS.n597 0.179351
R8551 VSS.n606 VSS.n587 0.17884
R8552 VSS.n538 VSS.n532 0.171734
R8553 VSS.n182 VSS.n181 0.164347
R8554 VSS.n583 VSS.n265 0.162752
R8555 VSS.n1640 VSS.n1426 0.16132
R8556 VSS.n665 VSS.n606 0.148914
R8557 VSS.n1986 VSS.n186 0.148437
R8558 VSS.n703 VSS.n597 0.148407
R8559 VSS.n706 VSS.n589 0.14764
R8560 VSS.n667 VSS.n601 0.147636
R8561 VSS.n707 VSS.n642 0.147572
R8562 VSS.n652 VSS.n613 0.147315
R8563 VSS.n683 VSS.n614 0.146496
R8564 VSS.n688 VSS.n639 0.146496
R8565 VSS.n1999 VSS.n1998 0.144519
R8566 VSS.n465 VSS.n464 0.134908
R8567 VSS.n572 VSS.n569 0.134908
R8568 VSS.n145 VSS.n144 0.133889
R8569 VSS.n145 VSS.n125 0.133889
R8570 VSS.n166 VSS.n125 0.133889
R8571 VSS.n173 VSS.n166 0.133889
R8572 VSS.n1391 VSS.n1384 0.133889
R8573 VSS.n1384 VSS.n1343 0.133889
R8574 VSS.n1366 VSS.n1343 0.133889
R8575 VSS.n1366 VSS.n1365 0.133889
R8576 VSS.n762 VSS.n761 0.13386
R8577 VSS.n576 VSS.n467 0.13386
R8578 VSS.n763 VSS.n762 0.111336
R8579 VSS.n576 VSS.n478 0.111336
R8580 VSS.n557 VSS.n538 0.103639
R8581 VSS.n388 VSS.n328 0.103577
R8582 VSS.n416 VSS.n328 0.101143
R8583 VSS.n1461 VSS.n188 0.09378
R8584 VSS VSS.n732 0.0853758
R8585 VSS.n382 VSS.n322 0.0839652
R8586 VSS.n760 VSS 0.0783672
R8587 VSS.n318 VSS.n317 0.0682391
R8588 VSS.n140 VSS.n127 0.0671947
R8589 VSS.n161 VSS.n127 0.0671947
R8590 VSS.n162 VSS.n161 0.0671947
R8591 VSS.n162 VSS.n124 0.0671947
R8592 VSS.n152 VSS.n130 0.0671947
R8593 VSS.n156 VSS.n152 0.0671947
R8594 VSS.n156 VSS.n155 0.0671947
R8595 VSS.n155 VSS.n123 0.0671947
R8596 VSS.n1380 VSS.n1342 0.0671947
R8597 VSS.n1380 VSS.n1379 0.0671947
R8598 VSS.n1379 VSS.n1345 0.0671947
R8599 VSS.n1361 VSS.n1345 0.0671947
R8600 VSS.n1350 VSS.n1341 0.0671947
R8601 VSS.n1374 VSS.n1350 0.0671947
R8602 VSS.n1374 VSS.n1373 0.0671947
R8603 VSS.n1373 VSS.n1351 0.0671947
R8604 VSS.n464 VSS.n463 0.0652409
R8605 VSS.n569 VSS.n568 0.0652409
R8606 VSS.n440 VSS.n401 0.0590655
R8607 VSS.n440 VSS.n399 0.0590655
R8608 VSS.n440 VSS.n397 0.0590655
R8609 VSS.n560 VSS.n559 0.0590655
R8610 VSS.n560 VSS.n492 0.0590655
R8611 VSS.n560 VSS.n490 0.0590655
R8612 VSS.n673 VSS.n657 0.0537317
R8613 VSS.n674 VSS.n673 0.0537317
R8614 VSS.n675 VSS.n674 0.0537317
R8615 VSS.n676 VSS.n675 0.0537317
R8616 VSS.n676 VSS.n648 0.0537317
R8617 VSS.n695 VSS.n648 0.0537317
R8618 VSS.n696 VSS.n695 0.0537317
R8619 VSS.n697 VSS.n696 0.0537317
R8620 VSS.n682 VSS.n617 0.0530556
R8621 VSS.n687 VSS.n636 0.0530556
R8622 VSS.n619 VSS.n618 0.0481667
R8623 VSS.n635 VSS.n634 0.0481667
R8624 VSS.n1986 VSS.n188 0.0445
R8625 VSS.n623 VSS.n622 0.0432778
R8626 VSS.n633 VSS.n630 0.0432778
R8627 VSS.n710 VSS.n587 0.0404962
R8628 VSS.n701 VSS.n594 0.0404962
R8629 VSS.n625 VSS.n624 0.0383889
R8630 VSS.n629 VSS.n628 0.0383889
R8631 VSS.n761 VSS.n466 0.0371667
R8632 VSS.n573 VSS.n467 0.0371667
R8633 VSS.n466 VSS.n465 0.0361191
R8634 VSS.n573 VSS.n572 0.0361191
R8635 VSS.n685 VSS.n625 0.0335
R8636 VSS.n685 VSS.n628 0.0335
R8637 VSS.n968 VSS.n933 0.0331154
R8638 VSS.n785 VSS.n784 0.0331154
R8639 VSS.n813 VSS.n797 0.0331154
R8640 VSS.n244 VSS.n228 0.0331154
R8641 VSS.n206 VSS.n205 0.0331154
R8642 VSS.n1137 VSS.n1136 0.0331154
R8643 VSS.n1512 VSS.n1149 0.0331154
R8644 VSS.n1534 VSS.n1447 0.0331154
R8645 VSS.n1575 VSS.n1178 0.0331154
R8646 VSS.n1597 VSS.n1435 0.0331154
R8647 VSS.n1197 VSS.n1196 0.0331154
R8648 VSS.n1427 VSS.n1209 0.0331154
R8649 VSS.n1333 VSS.n1316 0.0331154
R8650 VSS.n1227 VSS.n1226 0.0331154
R8651 VSS.n1270 VSS.n1239 0.0331154
R8652 VSS.n1253 VSS.n1252 0.0331154
R8653 VSS.n2019 VSS.n14 0.0331154
R8654 VSS.n967 VSS.n932 0.0331154
R8655 VSS.n1012 VSS.n1011 0.0331154
R8656 VSS.n998 VSS.n798 0.0331154
R8657 VSS.n246 VSS.n227 0.0331154
R8658 VSS.n1117 VSS.n1116 0.0331154
R8659 VSS.n1476 VSS.n1458 0.0331154
R8660 VSS.n1966 VSS.n1965 0.0331154
R8661 VSS.n1952 VSS.n1150 0.0331154
R8662 VSS.n1533 VSS.n1446 0.0331154
R8663 VSS.n1918 VSS.n1179 0.0331154
R8664 VSS.n1596 VSS.n1434 0.0331154
R8665 VSS.n1898 VSS.n1897 0.0331154
R8666 VSS.n1884 VSS.n1210 0.0331154
R8667 VSS.n1335 VSS.n1315 0.0331154
R8668 VSS.n1864 VSS.n1863 0.0331154
R8669 VSS.n1850 VSS.n1240 0.0331154
R8670 VSS.n1831 VSS.n1830 0.0331154
R8671 VSS.n2018 VSS.n13 0.0331154
R8672 VSS.n966 VSS.n931 0.0331154
R8673 VSS.n1013 VSS.n783 0.0331154
R8674 VSS.n997 VSS.n996 0.0331154
R8675 VSS.n1033 VSS.n226 0.0331154
R8676 VSS.n1118 VSS.n204 0.0331154
R8677 VSS.n1475 VSS.n1457 0.0331154
R8678 VSS.n1967 VSS.n1135 0.0331154
R8679 VSS.n1951 VSS.n1950 0.0331154
R8680 VSS.n1532 VSS.n1445 0.0331154
R8681 VSS.n1917 VSS.n1916 0.0331154
R8682 VSS.n1595 VSS.n1433 0.0331154
R8683 VSS.n1899 VSS.n1195 0.0331154
R8684 VSS.n1883 VSS.n1882 0.0331154
R8685 VSS.n1662 VSS.n1314 0.0331154
R8686 VSS.n1865 VSS.n1225 0.0331154
R8687 VSS.n1849 VSS.n1848 0.0331154
R8688 VSS.n1832 VSS.n1251 0.0331154
R8689 VSS.n2017 VSS.n12 0.0331154
R8690 VSS.n765 VSS.n321 0.0322928
R8691 VSS.n1633 VSS.n30 0.0306466
R8692 VSS.n950 VSS.n945 0.0300385
R8693 VSS.n950 VSS.n949 0.0300385
R8694 VSS.n949 VSS.n941 0.0300385
R8695 VSS.n958 VSS.n941 0.0300385
R8696 VSS.n958 VSS.n939 0.0300385
R8697 VSS.n962 VSS.n939 0.0300385
R8698 VSS.n962 VSS.n935 0.0300385
R8699 VSS.n968 VSS.n935 0.0300385
R8700 VSS.n972 VSS.n933 0.0300385
R8701 VSS.n972 VSS.n929 0.0300385
R8702 VSS.n978 VSS.n929 0.0300385
R8703 VSS.n978 VSS.n927 0.0300385
R8704 VSS.n982 VSS.n927 0.0300385
R8705 VSS.n982 VSS.n778 0.0300385
R8706 VSS.n1017 VSS.n778 0.0300385
R8707 VSS.n1017 VSS.n779 0.0300385
R8708 VSS.n784 VSS.n779 0.0300385
R8709 VSS.n786 VSS.n785 0.0300385
R8710 VSS.n842 VSS.n786 0.0300385
R8711 VSS.n842 VSS.n789 0.0300385
R8712 VSS.n790 VSS.n789 0.0300385
R8713 VSS.n791 VSS.n790 0.0300385
R8714 VSS.n828 VSS.n791 0.0300385
R8715 VSS.n828 VSS.n795 0.0300385
R8716 VSS.n796 VSS.n795 0.0300385
R8717 VSS.n797 VSS.n796 0.0300385
R8718 VSS.n813 VSS.n800 0.0300385
R8719 VSS.n801 VSS.n800 0.0300385
R8720 VSS.n802 VSS.n801 0.0300385
R8721 VSS.n922 VSS.n802 0.0300385
R8722 VSS.n922 VSS.n249 0.0300385
R8723 VSS.n1029 VSS.n249 0.0300385
R8724 VSS.n1029 VSS.n242 0.0300385
R8725 VSS.n1036 VSS.n242 0.0300385
R8726 VSS.n1036 VSS.n244 0.0300385
R8727 VSS.n1064 VSS.n228 0.0300385
R8728 VSS.n1064 VSS.n223 0.0300385
R8729 VSS.n1070 VSS.n223 0.0300385
R8730 VSS.n1071 VSS.n1070 0.0300385
R8731 VSS.n1071 VSS.n200 0.0300385
R8732 VSS.n201 VSS.n200 0.0300385
R8733 VSS.n202 VSS.n201 0.0300385
R8734 VSS.n213 VSS.n202 0.0300385
R8735 VSS.n213 VSS.n205 0.0300385
R8736 VSS.n1113 VSS.n206 0.0300385
R8737 VSS.n1113 VSS.n190 0.0300385
R8738 VSS.n1981 VSS.n190 0.0300385
R8739 VSS.n1981 VSS.n191 0.0300385
R8740 VSS.n1467 VSS.n191 0.0300385
R8741 VSS.n1471 VSS.n1470 0.0300385
R8742 VSS.n1477 VSS.n1464 0.0300385
R8743 VSS.n1480 VSS.n1459 0.0300385
R8744 VSS.n1480 VSS.n1455 0.0300385
R8745 VSS.n1486 VSS.n1455 0.0300385
R8746 VSS.n1487 VSS.n1486 0.0300385
R8747 VSS.n1487 VSS.n1131 0.0300385
R8748 VSS.n1132 VSS.n1131 0.0300385
R8749 VSS.n1133 VSS.n1132 0.0300385
R8750 VSS.n1492 VSS.n1133 0.0300385
R8751 VSS.n1492 VSS.n1136 0.0300385
R8752 VSS.n1138 VSS.n1137 0.0300385
R8753 VSS.n1499 VSS.n1138 0.0300385
R8754 VSS.n1499 VSS.n1141 0.0300385
R8755 VSS.n1142 VSS.n1141 0.0300385
R8756 VSS.n1143 VSS.n1142 0.0300385
R8757 VSS.n1506 VSS.n1143 0.0300385
R8758 VSS.n1506 VSS.n1147 0.0300385
R8759 VSS.n1148 VSS.n1147 0.0300385
R8760 VSS.n1149 VSS.n1148 0.0300385
R8761 VSS.n1512 VSS.n1152 0.0300385
R8762 VSS.n1153 VSS.n1152 0.0300385
R8763 VSS.n1154 VSS.n1153 0.0300385
R8764 VSS.n1520 VSS.n1154 0.0300385
R8765 VSS.n1522 VSS.n1520 0.0300385
R8766 VSS.n1522 VSS.n1453 0.0300385
R8767 VSS.n1528 VSS.n1453 0.0300385
R8768 VSS.n1528 VSS.n1449 0.0300385
R8769 VSS.n1534 VSS.n1449 0.0300385
R8770 VSS.n1541 VSS.n1447 0.0300385
R8771 VSS.n1541 VSS.n1443 0.0300385
R8772 VSS.n1547 VSS.n1443 0.0300385
R8773 VSS.n1548 VSS.n1547 0.0300385
R8774 VSS.n1548 VSS.n1160 0.0300385
R8775 VSS.n1161 VSS.n1160 0.0300385
R8776 VSS.n1162 VSS.n1161 0.0300385
R8777 VSS.n1555 VSS.n1162 0.0300385
R8778 VSS.n1555 VSS.n1165 0.0300385
R8779 VSS.n1166 VSS.n1165 0.0300385
R8780 VSS.n1167 VSS.n1166 0.0300385
R8781 VSS.n1562 VSS.n1167 0.0300385
R8782 VSS.n1562 VSS.n1170 0.0300385
R8783 VSS.n1171 VSS.n1170 0.0300385
R8784 VSS.n1172 VSS.n1171 0.0300385
R8785 VSS.n1568 VSS.n1172 0.0300385
R8786 VSS.n1568 VSS.n1176 0.0300385
R8787 VSS.n1177 VSS.n1176 0.0300385
R8788 VSS.n1178 VSS.n1177 0.0300385
R8789 VSS.n1575 VSS.n1181 0.0300385
R8790 VSS.n1182 VSS.n1181 0.0300385
R8791 VSS.n1183 VSS.n1182 0.0300385
R8792 VSS.n1583 VSS.n1183 0.0300385
R8793 VSS.n1585 VSS.n1583 0.0300385
R8794 VSS.n1585 VSS.n1441 0.0300385
R8795 VSS.n1591 VSS.n1441 0.0300385
R8796 VSS.n1591 VSS.n1437 0.0300385
R8797 VSS.n1597 VSS.n1437 0.0300385
R8798 VSS.n1603 VSS.n1435 0.0300385
R8799 VSS.n1603 VSS.n1430 0.0300385
R8800 VSS.n1609 VSS.n1430 0.0300385
R8801 VSS.n1610 VSS.n1609 0.0300385
R8802 VSS.n1610 VSS.n1191 0.0300385
R8803 VSS.n1192 VSS.n1191 0.0300385
R8804 VSS.n1193 VSS.n1192 0.0300385
R8805 VSS.n1616 VSS.n1193 0.0300385
R8806 VSS.n1616 VSS.n1196 0.0300385
R8807 VSS.n1198 VSS.n1197 0.0300385
R8808 VSS.n1623 VSS.n1198 0.0300385
R8809 VSS.n1623 VSS.n1201 0.0300385
R8810 VSS.n1202 VSS.n1201 0.0300385
R8811 VSS.n1203 VSS.n1202 0.0300385
R8812 VSS.n1628 VSS.n1203 0.0300385
R8813 VSS.n1628 VSS.n1207 0.0300385
R8814 VSS.n1208 VSS.n1207 0.0300385
R8815 VSS.n1209 VSS.n1208 0.0300385
R8816 VSS.n1427 VSS.n1212 0.0300385
R8817 VSS.n1213 VSS.n1212 0.0300385
R8818 VSS.n1214 VSS.n1213 0.0300385
R8819 VSS.n1647 VSS.n1214 0.0300385
R8820 VSS.n1647 VSS.n1337 0.0300385
R8821 VSS.n1658 VSS.n1337 0.0300385
R8822 VSS.n1658 VSS.n1332 0.0300385
R8823 VSS.n1665 VSS.n1332 0.0300385
R8824 VSS.n1665 VSS.n1333 0.0300385
R8825 VSS.n1683 VSS.n1316 0.0300385
R8826 VSS.n1683 VSS.n1312 0.0300385
R8827 VSS.n1689 VSS.n1312 0.0300385
R8828 VSS.n1690 VSS.n1689 0.0300385
R8829 VSS.n1690 VSS.n1221 0.0300385
R8830 VSS.n1222 VSS.n1221 0.0300385
R8831 VSS.n1223 VSS.n1222 0.0300385
R8832 VSS.n1299 VSS.n1223 0.0300385
R8833 VSS.n1299 VSS.n1226 0.0300385
R8834 VSS.n1228 VSS.n1227 0.0300385
R8835 VSS.n1734 VSS.n1228 0.0300385
R8836 VSS.n1734 VSS.n1231 0.0300385
R8837 VSS.n1232 VSS.n1231 0.0300385
R8838 VSS.n1233 VSS.n1232 0.0300385
R8839 VSS.n1758 VSS.n1233 0.0300385
R8840 VSS.n1758 VSS.n1237 0.0300385
R8841 VSS.n1238 VSS.n1237 0.0300385
R8842 VSS.n1239 VSS.n1238 0.0300385
R8843 VSS.n1270 VSS.n1242 0.0300385
R8844 VSS.n1243 VSS.n1242 0.0300385
R8845 VSS.n1244 VSS.n1243 0.0300385
R8846 VSS.n1262 VSS.n1244 0.0300385
R8847 VSS.n1262 VSS.n1247 0.0300385
R8848 VSS.n1248 VSS.n1247 0.0300385
R8849 VSS.n1249 VSS.n1248 0.0300385
R8850 VSS.n1815 VSS.n1249 0.0300385
R8851 VSS.n1815 VSS.n1252 0.0300385
R8852 VSS.n1827 VSS.n1253 0.0300385
R8853 VSS.n1827 VSS.n26 0.0300385
R8854 VSS.n2002 VSS.n26 0.0300385
R8855 VSS.n2002 VSS.n22 0.0300385
R8856 VSS.n2009 VSS.n22 0.0300385
R8857 VSS.n2009 VSS.n20 0.0300385
R8858 VSS.n2013 VSS.n20 0.0300385
R8859 VSS.n2013 VSS.n16 0.0300385
R8860 VSS.n2019 VSS.n16 0.0300385
R8861 VSS.n2024 VSS.n14 0.0300385
R8862 VSS.n2024 VSS.n10 0.0300385
R8863 VSS.n2030 VSS.n10 0.0300385
R8864 VSS.n2031 VSS.n2030 0.0300385
R8865 VSS.n2031 VSS.n4 0.0300385
R8866 VSS.n5 VSS.n4 0.0300385
R8867 VSS.n6 VSS.n5 0.0300385
R8868 VSS.n8 VSS.n6 0.0300385
R8869 VSS.n951 VSS.n944 0.0300385
R8870 VSS.n951 VSS.n942 0.0300385
R8871 VSS.n955 VSS.n942 0.0300385
R8872 VSS.n957 VSS.n955 0.0300385
R8873 VSS.n957 VSS.n938 0.0300385
R8874 VSS.n963 VSS.n938 0.0300385
R8875 VSS.n963 VSS.n936 0.0300385
R8876 VSS.n967 VSS.n936 0.0300385
R8877 VSS.n973 VSS.n932 0.0300385
R8878 VSS.n973 VSS.n930 0.0300385
R8879 VSS.n977 VSS.n930 0.0300385
R8880 VSS.n977 VSS.n926 0.0300385
R8881 VSS.n983 VSS.n926 0.0300385
R8882 VSS.n983 VSS.n780 0.0300385
R8883 VSS.n1016 VSS.n780 0.0300385
R8884 VSS.n1016 VSS.n781 0.0300385
R8885 VSS.n1012 VSS.n781 0.0300385
R8886 VSS.n1011 VSS.n1010 0.0300385
R8887 VSS.n1010 VSS.n787 0.0300385
R8888 VSS.n1006 VSS.n787 0.0300385
R8889 VSS.n1006 VSS.n1005 0.0300385
R8890 VSS.n1005 VSS.n1004 0.0300385
R8891 VSS.n1004 VSS.n792 0.0300385
R8892 VSS.n1000 VSS.n792 0.0300385
R8893 VSS.n1000 VSS.n999 0.0300385
R8894 VSS.n999 VSS.n998 0.0300385
R8895 VSS.n994 VSS.n798 0.0300385
R8896 VSS.n994 VSS.n993 0.0300385
R8897 VSS.n993 VSS.n992 0.0300385
R8898 VSS.n992 VSS.n923 0.0300385
R8899 VSS.n923 VSS.n248 0.0300385
R8900 VSS.n1030 VSS.n248 0.0300385
R8901 VSS.n1030 VSS.n245 0.0300385
R8902 VSS.n1035 VSS.n245 0.0300385
R8903 VSS.n1035 VSS.n246 0.0300385
R8904 VSS.n1065 VSS.n227 0.0300385
R8905 VSS.n1065 VSS.n225 0.0300385
R8906 VSS.n1069 VSS.n225 0.0300385
R8907 VSS.n1069 VSS.n199 0.0300385
R8908 VSS.n1123 VSS.n199 0.0300385
R8909 VSS.n1123 VSS.n1122 0.0300385
R8910 VSS.n1122 VSS.n1121 0.0300385
R8911 VSS.n1121 VSS.n203 0.0300385
R8912 VSS.n1117 VSS.n203 0.0300385
R8913 VSS.n1116 VSS.n1115 0.0300385
R8914 VSS.n1115 VSS.n192 0.0300385
R8915 VSS.n1980 VSS.n192 0.0300385
R8916 VSS.n1980 VSS.n193 0.0300385
R8917 VSS.n1468 VSS.n193 0.0300385
R8918 VSS.n1469 VSS.n1468 0.0300385
R8919 VSS.n1472 VSS.n1469 0.0300385
R8920 VSS.n1472 VSS.n1465 0.0300385
R8921 VSS.n1476 VSS.n1465 0.0300385
R8922 VSS.n1481 VSS.n1458 0.0300385
R8923 VSS.n1481 VSS.n1456 0.0300385
R8924 VSS.n1485 VSS.n1456 0.0300385
R8925 VSS.n1485 VSS.n1130 0.0300385
R8926 VSS.n1972 VSS.n1130 0.0300385
R8927 VSS.n1972 VSS.n1971 0.0300385
R8928 VSS.n1971 VSS.n1970 0.0300385
R8929 VSS.n1970 VSS.n1134 0.0300385
R8930 VSS.n1966 VSS.n1134 0.0300385
R8931 VSS.n1965 VSS.n1964 0.0300385
R8932 VSS.n1964 VSS.n1139 0.0300385
R8933 VSS.n1960 VSS.n1139 0.0300385
R8934 VSS.n1960 VSS.n1959 0.0300385
R8935 VSS.n1959 VSS.n1958 0.0300385
R8936 VSS.n1958 VSS.n1144 0.0300385
R8937 VSS.n1954 VSS.n1144 0.0300385
R8938 VSS.n1954 VSS.n1953 0.0300385
R8939 VSS.n1953 VSS.n1952 0.0300385
R8940 VSS.n1948 VSS.n1150 0.0300385
R8941 VSS.n1948 VSS.n1947 0.0300385
R8942 VSS.n1947 VSS.n1946 0.0300385
R8943 VSS.n1946 VSS.n1155 0.0300385
R8944 VSS.n1521 VSS.n1155 0.0300385
R8945 VSS.n1521 VSS.n1452 0.0300385
R8946 VSS.n1529 VSS.n1452 0.0300385
R8947 VSS.n1529 VSS.n1450 0.0300385
R8948 VSS.n1533 VSS.n1450 0.0300385
R8949 VSS.n1542 VSS.n1446 0.0300385
R8950 VSS.n1542 VSS.n1444 0.0300385
R8951 VSS.n1546 VSS.n1444 0.0300385
R8952 VSS.n1546 VSS.n1159 0.0300385
R8953 VSS.n1938 VSS.n1159 0.0300385
R8954 VSS.n1938 VSS.n1937 0.0300385
R8955 VSS.n1937 VSS.n1936 0.0300385
R8956 VSS.n1936 VSS.n1163 0.0300385
R8957 VSS.n1932 VSS.n1163 0.0300385
R8958 VSS.n1932 VSS.n1931 0.0300385
R8959 VSS.n1931 VSS.n1930 0.0300385
R8960 VSS.n1930 VSS.n1168 0.0300385
R8961 VSS.n1926 VSS.n1168 0.0300385
R8962 VSS.n1926 VSS.n1925 0.0300385
R8963 VSS.n1925 VSS.n1924 0.0300385
R8964 VSS.n1924 VSS.n1173 0.0300385
R8965 VSS.n1920 VSS.n1173 0.0300385
R8966 VSS.n1920 VSS.n1919 0.0300385
R8967 VSS.n1919 VSS.n1918 0.0300385
R8968 VSS.n1914 VSS.n1179 0.0300385
R8969 VSS.n1914 VSS.n1913 0.0300385
R8970 VSS.n1913 VSS.n1912 0.0300385
R8971 VSS.n1912 VSS.n1184 0.0300385
R8972 VSS.n1584 VSS.n1184 0.0300385
R8973 VSS.n1584 VSS.n1440 0.0300385
R8974 VSS.n1592 VSS.n1440 0.0300385
R8975 VSS.n1592 VSS.n1438 0.0300385
R8976 VSS.n1596 VSS.n1438 0.0300385
R8977 VSS.n1604 VSS.n1434 0.0300385
R8978 VSS.n1604 VSS.n1432 0.0300385
R8979 VSS.n1608 VSS.n1432 0.0300385
R8980 VSS.n1608 VSS.n1190 0.0300385
R8981 VSS.n1904 VSS.n1190 0.0300385
R8982 VSS.n1904 VSS.n1903 0.0300385
R8983 VSS.n1903 VSS.n1902 0.0300385
R8984 VSS.n1902 VSS.n1194 0.0300385
R8985 VSS.n1898 VSS.n1194 0.0300385
R8986 VSS.n1897 VSS.n1896 0.0300385
R8987 VSS.n1896 VSS.n1199 0.0300385
R8988 VSS.n1892 VSS.n1199 0.0300385
R8989 VSS.n1892 VSS.n1891 0.0300385
R8990 VSS.n1891 VSS.n1890 0.0300385
R8991 VSS.n1890 VSS.n1204 0.0300385
R8992 VSS.n1886 VSS.n1204 0.0300385
R8993 VSS.n1886 VSS.n1885 0.0300385
R8994 VSS.n1885 VSS.n1884 0.0300385
R8995 VSS.n1880 VSS.n1210 0.0300385
R8996 VSS.n1880 VSS.n1879 0.0300385
R8997 VSS.n1879 VSS.n1878 0.0300385
R8998 VSS.n1878 VSS.n1215 0.0300385
R8999 VSS.n1336 VSS.n1215 0.0300385
R9000 VSS.n1659 VSS.n1336 0.0300385
R9001 VSS.n1659 VSS.n1334 0.0300385
R9002 VSS.n1664 VSS.n1334 0.0300385
R9003 VSS.n1664 VSS.n1335 0.0300385
R9004 VSS.n1684 VSS.n1315 0.0300385
R9005 VSS.n1684 VSS.n1313 0.0300385
R9006 VSS.n1688 VSS.n1313 0.0300385
R9007 VSS.n1688 VSS.n1220 0.0300385
R9008 VSS.n1870 VSS.n1220 0.0300385
R9009 VSS.n1870 VSS.n1869 0.0300385
R9010 VSS.n1869 VSS.n1868 0.0300385
R9011 VSS.n1868 VSS.n1224 0.0300385
R9012 VSS.n1864 VSS.n1224 0.0300385
R9013 VSS.n1863 VSS.n1862 0.0300385
R9014 VSS.n1862 VSS.n1229 0.0300385
R9015 VSS.n1858 VSS.n1229 0.0300385
R9016 VSS.n1858 VSS.n1857 0.0300385
R9017 VSS.n1857 VSS.n1856 0.0300385
R9018 VSS.n1856 VSS.n1234 0.0300385
R9019 VSS.n1852 VSS.n1234 0.0300385
R9020 VSS.n1852 VSS.n1851 0.0300385
R9021 VSS.n1851 VSS.n1850 0.0300385
R9022 VSS.n1846 VSS.n1240 0.0300385
R9023 VSS.n1846 VSS.n1845 0.0300385
R9024 VSS.n1845 VSS.n1844 0.0300385
R9025 VSS.n1844 VSS.n1245 0.0300385
R9026 VSS.n1837 VSS.n1245 0.0300385
R9027 VSS.n1837 VSS.n1836 0.0300385
R9028 VSS.n1836 VSS.n1835 0.0300385
R9029 VSS.n1835 VSS.n1250 0.0300385
R9030 VSS.n1831 VSS.n1250 0.0300385
R9031 VSS.n1830 VSS.n1829 0.0300385
R9032 VSS.n1829 VSS.n25 0.0300385
R9033 VSS.n2003 VSS.n25 0.0300385
R9034 VSS.n2003 VSS.n23 0.0300385
R9035 VSS.n2008 VSS.n23 0.0300385
R9036 VSS.n2008 VSS.n19 0.0300385
R9037 VSS.n2014 VSS.n19 0.0300385
R9038 VSS.n2014 VSS.n17 0.0300385
R9039 VSS.n2018 VSS.n17 0.0300385
R9040 VSS.n2025 VSS.n13 0.0300385
R9041 VSS.n2025 VSS.n11 0.0300385
R9042 VSS.n2029 VSS.n11 0.0300385
R9043 VSS.n2029 VSS.n3 0.0300385
R9044 VSS.n2041 VSS.n3 0.0300385
R9045 VSS.n2041 VSS.n2040 0.0300385
R9046 VSS.n2040 VSS.n2039 0.0300385
R9047 VSS.n2039 VSS.n7 0.0300385
R9048 VSS.n953 VSS.n952 0.0300385
R9049 VSS.n954 VSS.n953 0.0300385
R9050 VSS.n956 VSS.n937 0.0300385
R9051 VSS.n964 VSS.n937 0.0300385
R9052 VSS.n965 VSS.n964 0.0300385
R9053 VSS.n966 VSS.n965 0.0300385
R9054 VSS.n974 VSS.n931 0.0300385
R9055 VSS.n975 VSS.n974 0.0300385
R9056 VSS.n976 VSS.n975 0.0300385
R9057 VSS.n976 VSS.n925 0.0300385
R9058 VSS.n984 VSS.n782 0.0300385
R9059 VSS.n1015 VSS.n782 0.0300385
R9060 VSS.n1015 VSS.n1014 0.0300385
R9061 VSS.n1014 VSS.n1013 0.0300385
R9062 VSS.n1009 VSS.n783 0.0300385
R9063 VSS.n1009 VSS.n1008 0.0300385
R9064 VSS.n1008 VSS.n1007 0.0300385
R9065 VSS.n1007 VSS.n788 0.0300385
R9066 VSS.n1003 VSS.n1002 0.0300385
R9067 VSS.n1002 VSS.n1001 0.0300385
R9068 VSS.n1001 VSS.n794 0.0300385
R9069 VSS.n997 VSS.n794 0.0300385
R9070 VSS.n996 VSS.n995 0.0300385
R9071 VSS.n995 VSS.n799 0.0300385
R9072 VSS.n991 VSS.n799 0.0300385
R9073 VSS.n991 VSS.n990 0.0300385
R9074 VSS.n1031 VSS.n247 0.0300385
R9075 VSS.n1032 VSS.n1031 0.0300385
R9076 VSS.n1034 VSS.n1032 0.0300385
R9077 VSS.n1034 VSS.n1033 0.0300385
R9078 VSS.n1066 VSS.n226 0.0300385
R9079 VSS.n1067 VSS.n1066 0.0300385
R9080 VSS.n1068 VSS.n1067 0.0300385
R9081 VSS.n1068 VSS.n197 0.0300385
R9082 VSS.n1124 VSS.n198 0.0300385
R9083 VSS.n1120 VSS.n198 0.0300385
R9084 VSS.n1120 VSS.n1119 0.0300385
R9085 VSS.n1119 VSS.n1118 0.0300385
R9086 VSS.n1114 VSS.n204 0.0300385
R9087 VSS.n1114 VSS.n194 0.0300385
R9088 VSS.n1979 VSS.n194 0.0300385
R9089 VSS.n1979 VSS.n1978 0.0300385
R9090 VSS.n1466 VSS.n195 0.0300385
R9091 VSS.n1473 VSS.n1466 0.0300385
R9092 VSS.n1474 VSS.n1473 0.0300385
R9093 VSS.n1475 VSS.n1474 0.0300385
R9094 VSS.n1482 VSS.n1457 0.0300385
R9095 VSS.n1483 VSS.n1482 0.0300385
R9096 VSS.n1484 VSS.n1483 0.0300385
R9097 VSS.n1484 VSS.n1128 0.0300385
R9098 VSS.n1973 VSS.n1129 0.0300385
R9099 VSS.n1969 VSS.n1129 0.0300385
R9100 VSS.n1969 VSS.n1968 0.0300385
R9101 VSS.n1968 VSS.n1967 0.0300385
R9102 VSS.n1963 VSS.n1135 0.0300385
R9103 VSS.n1963 VSS.n1962 0.0300385
R9104 VSS.n1962 VSS.n1961 0.0300385
R9105 VSS.n1961 VSS.n1140 0.0300385
R9106 VSS.n1957 VSS.n1956 0.0300385
R9107 VSS.n1956 VSS.n1955 0.0300385
R9108 VSS.n1955 VSS.n1146 0.0300385
R9109 VSS.n1951 VSS.n1146 0.0300385
R9110 VSS.n1950 VSS.n1949 0.0300385
R9111 VSS.n1949 VSS.n1151 0.0300385
R9112 VSS.n1945 VSS.n1151 0.0300385
R9113 VSS.n1945 VSS.n1944 0.0300385
R9114 VSS.n1451 VSS.n1156 0.0300385
R9115 VSS.n1530 VSS.n1451 0.0300385
R9116 VSS.n1531 VSS.n1530 0.0300385
R9117 VSS.n1532 VSS.n1531 0.0300385
R9118 VSS.n1543 VSS.n1445 0.0300385
R9119 VSS.n1544 VSS.n1543 0.0300385
R9120 VSS.n1545 VSS.n1544 0.0300385
R9121 VSS.n1545 VSS.n1157 0.0300385
R9122 VSS.n1939 VSS.n1158 0.0300385
R9123 VSS.n1935 VSS.n1158 0.0300385
R9124 VSS.n1935 VSS.n1934 0.0300385
R9125 VSS.n1934 VSS.n1933 0.0300385
R9126 VSS.n1933 VSS.n1164 0.0300385
R9127 VSS.n1929 VSS.n1164 0.0300385
R9128 VSS.n1929 VSS.n1928 0.0300385
R9129 VSS.n1928 VSS.n1927 0.0300385
R9130 VSS.n1927 VSS.n1169 0.0300385
R9131 VSS.n1923 VSS.n1922 0.0300385
R9132 VSS.n1922 VSS.n1921 0.0300385
R9133 VSS.n1921 VSS.n1175 0.0300385
R9134 VSS.n1917 VSS.n1175 0.0300385
R9135 VSS.n1916 VSS.n1915 0.0300385
R9136 VSS.n1915 VSS.n1180 0.0300385
R9137 VSS.n1911 VSS.n1180 0.0300385
R9138 VSS.n1911 VSS.n1910 0.0300385
R9139 VSS.n1439 VSS.n1185 0.0300385
R9140 VSS.n1593 VSS.n1439 0.0300385
R9141 VSS.n1594 VSS.n1593 0.0300385
R9142 VSS.n1595 VSS.n1594 0.0300385
R9143 VSS.n1605 VSS.n1433 0.0300385
R9144 VSS.n1606 VSS.n1605 0.0300385
R9145 VSS.n1607 VSS.n1606 0.0300385
R9146 VSS.n1607 VSS.n1188 0.0300385
R9147 VSS.n1905 VSS.n1189 0.0300385
R9148 VSS.n1901 VSS.n1189 0.0300385
R9149 VSS.n1901 VSS.n1900 0.0300385
R9150 VSS.n1900 VSS.n1899 0.0300385
R9151 VSS.n1895 VSS.n1195 0.0300385
R9152 VSS.n1895 VSS.n1894 0.0300385
R9153 VSS.n1894 VSS.n1893 0.0300385
R9154 VSS.n1893 VSS.n1200 0.0300385
R9155 VSS.n1889 VSS.n1888 0.0300385
R9156 VSS.n1888 VSS.n1887 0.0300385
R9157 VSS.n1887 VSS.n1206 0.0300385
R9158 VSS.n1883 VSS.n1206 0.0300385
R9159 VSS.n1882 VSS.n1881 0.0300385
R9160 VSS.n1881 VSS.n1211 0.0300385
R9161 VSS.n1877 VSS.n1211 0.0300385
R9162 VSS.n1877 VSS.n1876 0.0300385
R9163 VSS.n1660 VSS.n1216 0.0300385
R9164 VSS.n1661 VSS.n1660 0.0300385
R9165 VSS.n1663 VSS.n1661 0.0300385
R9166 VSS.n1663 VSS.n1662 0.0300385
R9167 VSS.n1685 VSS.n1314 0.0300385
R9168 VSS.n1686 VSS.n1685 0.0300385
R9169 VSS.n1687 VSS.n1686 0.0300385
R9170 VSS.n1687 VSS.n1218 0.0300385
R9171 VSS.n1871 VSS.n1219 0.0300385
R9172 VSS.n1867 VSS.n1219 0.0300385
R9173 VSS.n1867 VSS.n1866 0.0300385
R9174 VSS.n1866 VSS.n1865 0.0300385
R9175 VSS.n1861 VSS.n1225 0.0300385
R9176 VSS.n1861 VSS.n1860 0.0300385
R9177 VSS.n1860 VSS.n1859 0.0300385
R9178 VSS.n1859 VSS.n1230 0.0300385
R9179 VSS.n1855 VSS.n1854 0.0300385
R9180 VSS.n1854 VSS.n1853 0.0300385
R9181 VSS.n1853 VSS.n1236 0.0300385
R9182 VSS.n1849 VSS.n1236 0.0300385
R9183 VSS.n1848 VSS.n1847 0.0300385
R9184 VSS.n1847 VSS.n1241 0.0300385
R9185 VSS.n1843 VSS.n1241 0.0300385
R9186 VSS.n1843 VSS.n1842 0.0300385
R9187 VSS.n1838 VSS.n1246 0.0300385
R9188 VSS.n1834 VSS.n1246 0.0300385
R9189 VSS.n1834 VSS.n1833 0.0300385
R9190 VSS.n1833 VSS.n1832 0.0300385
R9191 VSS.n1828 VSS.n1251 0.0300385
R9192 VSS.n1828 VSS.n24 0.0300385
R9193 VSS.n2004 VSS.n24 0.0300385
R9194 VSS.n2005 VSS.n2004 0.0300385
R9195 VSS.n2007 VSS.n18 0.0300385
R9196 VSS.n2015 VSS.n18 0.0300385
R9197 VSS.n2016 VSS.n2015 0.0300385
R9198 VSS.n2017 VSS.n2016 0.0300385
R9199 VSS.n2026 VSS.n12 0.0300385
R9200 VSS.n2027 VSS.n2026 0.0300385
R9201 VSS.n2028 VSS.n2027 0.0300385
R9202 VSS.n2028 VSS.n1 0.0300385
R9203 VSS.n2042 VSS.n2 0.0300385
R9204 VSS.n2038 VSS.n2 0.0300385
R9205 VSS.n624 VSS.n623 0.0286111
R9206 VSS.n630 VSS.n629 0.0286111
R9207 VSS.n1988 VSS.n1987 0.0284666
R9208 VSS.n1479 VSS.n1461 0.02646
R9209 VSS.n1997 VSS.n49 0.0248767
R9210 VSS.n622 VSS.n619 0.0237222
R9211 VSS.n634 VSS.n633 0.0237222
R9212 VSS.n760 VSS.n759 0.0214524
R9213 VSS.n732 VSS.n731 0.0214524
R9214 VSS.n769 VSS.n286 0.0203079
R9215 VSS.n769 VSS.n287 0.0203079
R9216 VSS.n618 VSS.n617 0.0188333
R9217 VSS.n636 VSS.n635 0.0188333
R9218 VSS.n538 VSS.n484 0.0175172
R9219 VSS.n1478 VSS.n1477 0.0171903
R9220 VSS.n1478 VSS.n1459 0.0171903
R9221 VSS.n1467 VSS.n1462 0.0156729
R9222 VSS.n1471 VSS.n1463 0.0156729
R9223 VSS.n1464 VSS.n1463 0.0156729
R9224 VSS.n1470 VSS.n1462 0.0156729
R9225 VSS.n2036 VSS.n8 0.0156388
R9226 VSS.n946 VSS.n945 0.0156388
R9227 VSS.n2037 VSS.n7 0.0155778
R9228 VSS.n944 VSS.n943 0.0155778
R9229 VSS.n954 VSS.n924 0.0152692
R9230 VSS.n956 VSS.n924 0.0152692
R9231 VSS.n985 VSS.n925 0.0152692
R9232 VSS.n985 VSS.n984 0.0152692
R9233 VSS.n793 VSS.n788 0.0152692
R9234 VSS.n1003 VSS.n793 0.0152692
R9235 VSS.n990 VSS.n989 0.0152692
R9236 VSS.n989 VSS.n247 0.0152692
R9237 VSS.n1125 VSS.n197 0.0152692
R9238 VSS.n1125 VSS.n1124 0.0152692
R9239 VSS.n1978 VSS.n1977 0.0152692
R9240 VSS.n1977 VSS.n195 0.0152692
R9241 VSS.n1974 VSS.n1128 0.0152692
R9242 VSS.n1974 VSS.n1973 0.0152692
R9243 VSS.n1145 VSS.n1140 0.0152692
R9244 VSS.n1957 VSS.n1145 0.0152692
R9245 VSS.n1944 VSS.n1943 0.0152692
R9246 VSS.n1943 VSS.n1156 0.0152692
R9247 VSS.n1940 VSS.n1157 0.0152692
R9248 VSS.n1940 VSS.n1939 0.0152692
R9249 VSS.n1174 VSS.n1169 0.0152692
R9250 VSS.n1923 VSS.n1174 0.0152692
R9251 VSS.n1910 VSS.n1909 0.0152692
R9252 VSS.n1909 VSS.n1185 0.0152692
R9253 VSS.n1906 VSS.n1188 0.0152692
R9254 VSS.n1906 VSS.n1905 0.0152692
R9255 VSS.n1205 VSS.n1200 0.0152692
R9256 VSS.n1889 VSS.n1205 0.0152692
R9257 VSS.n1876 VSS.n1875 0.0152692
R9258 VSS.n1875 VSS.n1216 0.0152692
R9259 VSS.n1872 VSS.n1218 0.0152692
R9260 VSS.n1872 VSS.n1871 0.0152692
R9261 VSS.n1235 VSS.n1230 0.0152692
R9262 VSS.n1855 VSS.n1235 0.0152692
R9263 VSS.n1842 VSS.n1841 0.0152692
R9264 VSS.n1841 VSS.n1838 0.0152692
R9265 VSS.n2006 VSS.n2005 0.0152692
R9266 VSS.n2007 VSS.n2006 0.0152692
R9267 VSS.n2043 VSS.n1 0.0152692
R9268 VSS.n2043 VSS.n2042 0.0152692
R9269 VSS.n1674 VSS.n1326 0.014259
R9270 VSS.n1679 VSS.n1326 0.014259
R9271 VSS.n1679 VSS.n1309 0.014259
R9272 VSS.n1699 VSS.n1309 0.014259
R9273 VSS.n1700 VSS.n1699 0.014259
R9274 VSS.n1700 VSS.n1307 0.014259
R9275 VSS.n1704 VSS.n1307 0.014259
R9276 VSS.n1704 VSS.n1297 0.014259
R9277 VSS.n1721 VSS.n1297 0.014259
R9278 VSS.n1721 VSS.n1295 0.014259
R9279 VSS.n1726 VSS.n1295 0.014259
R9280 VSS.n1726 VSS.n1288 0.014259
R9281 VSS.n1744 VSS.n1288 0.014259
R9282 VSS.n1745 VSS.n1744 0.014259
R9283 VSS.n1745 VSS.n1286 0.014259
R9284 VSS.n1749 VSS.n1286 0.014259
R9285 VSS.n1749 VSS.n1277 0.014259
R9286 VSS.n1767 VSS.n1277 0.014259
R9287 VSS.n1767 VSS.n1275 0.014259
R9288 VSS.n1771 VSS.n1275 0.014259
R9289 VSS.n1771 VSS.n1268 0.014259
R9290 VSS.n1787 VSS.n1268 0.014259
R9291 VSS.n1787 VSS.n1266 0.014259
R9292 VSS.n1791 VSS.n1266 0.014259
R9293 VSS.n1791 VSS.n1260 0.014259
R9294 VSS.n1808 VSS.n1260 0.014259
R9295 VSS.n1808 VSS.n1258 0.014259
R9296 VSS.n1673 VSS.n1327 0.014259
R9297 VSS.n1673 VSS.n1325 0.014259
R9298 VSS.n1680 VSS.n1325 0.014259
R9299 VSS.n1680 VSS.n1310 0.014259
R9300 VSS.n1698 VSS.n1310 0.014259
R9301 VSS.n1698 VSS.n1306 0.014259
R9302 VSS.n1706 VSS.n1306 0.014259
R9303 VSS.n1706 VSS.n1705 0.014259
R9304 VSS.n1705 VSS.n1298 0.014259
R9305 VSS.n1720 VSS.n1298 0.014259
R9306 VSS.n1720 VSS.n1294 0.014259
R9307 VSS.n1727 VSS.n1294 0.014259
R9308 VSS.n1727 VSS.n1290 0.014259
R9309 VSS.n1743 VSS.n1290 0.014259
R9310 VSS.n1743 VSS.n1285 0.014259
R9311 VSS.n1751 VSS.n1285 0.014259
R9312 VSS.n1751 VSS.n1750 0.014259
R9313 VSS.n1750 VSS.n1278 0.014259
R9314 VSS.n1766 VSS.n1278 0.014259
R9315 VSS.n1766 VSS.n1274 0.014259
R9316 VSS.n1772 VSS.n1274 0.014259
R9317 VSS.n1772 VSS.n1269 0.014259
R9318 VSS.n1786 VSS.n1269 0.014259
R9319 VSS.n1786 VSS.n1265 0.014259
R9320 VSS.n1792 VSS.n1265 0.014259
R9321 VSS.n1792 VSS.n1261 0.014259
R9322 VSS.n1807 VSS.n1261 0.014259
R9323 VSS.n1807 VSS.n1257 0.014259
R9324 VSS.n1811 VSS.n1257 0.014259
R9325 VSS.n860 VSS.n832 0.014259
R9326 VSS.n864 VSS.n832 0.014259
R9327 VSS.n864 VSS.n822 0.014259
R9328 VSS.n880 VSS.n822 0.014259
R9329 VSS.n880 VSS.n820 0.014259
R9330 VSS.n884 VSS.n820 0.014259
R9331 VSS.n884 VSS.n811 0.014259
R9332 VSS.n898 VSS.n811 0.014259
R9333 VSS.n898 VSS.n809 0.014259
R9334 VSS.n911 VSS.n809 0.014259
R9335 VSS.n911 VSS.n910 0.014259
R9336 VSS.n910 VSS.n909 0.014259
R9337 VSS.n909 VSS.n907 0.014259
R9338 VSS.n907 VSS.n238 0.014259
R9339 VSS.n1039 VSS.n238 0.014259
R9340 VSS.n1040 VSS.n1039 0.014259
R9341 VSS.n1040 VSS.n234 0.014259
R9342 VSS.n235 VSS.n234 0.014259
R9343 VSS.n236 VSS.n235 0.014259
R9344 VSS.n1046 VSS.n236 0.014259
R9345 VSS.n1046 VSS.n220 0.014259
R9346 VSS.n1082 VSS.n220 0.014259
R9347 VSS.n1082 VSS.n218 0.014259
R9348 VSS.n1086 VSS.n218 0.014259
R9349 VSS.n1086 VSS.n211 0.014259
R9350 VSS.n1103 VSS.n211 0.014259
R9351 VSS.n1103 VSS.n209 0.014259
R9352 VSS.n859 VSS.n833 0.014259
R9353 VSS.n859 VSS.n831 0.014259
R9354 VSS.n865 VSS.n831 0.014259
R9355 VSS.n865 VSS.n823 0.014259
R9356 VSS.n879 VSS.n823 0.014259
R9357 VSS.n879 VSS.n819 0.014259
R9358 VSS.n885 VSS.n819 0.014259
R9359 VSS.n885 VSS.n812 0.014259
R9360 VSS.n897 VSS.n812 0.014259
R9361 VSS.n897 VSS.n808 0.014259
R9362 VSS.n912 VSS.n808 0.014259
R9363 VSS.n912 VSS.n804 0.014259
R9364 VSS.n908 VSS.n804 0.014259
R9365 VSS.n908 VSS.n251 0.014259
R9366 VSS.n251 VSS.n239 0.014259
R9367 VSS.n1038 VSS.n239 0.014259
R9368 VSS.n1038 VSS.n233 0.014259
R9369 VSS.n1056 VSS.n233 0.014259
R9370 VSS.n1056 VSS.n1055 0.014259
R9371 VSS.n1055 VSS.n1054 0.014259
R9372 VSS.n1054 VSS.n1053 0.014259
R9373 VSS.n1053 VSS.n221 0.014259
R9374 VSS.n1081 VSS.n221 0.014259
R9375 VSS.n1081 VSS.n217 0.014259
R9376 VSS.n1087 VSS.n217 0.014259
R9377 VSS.n1087 VSS.n212 0.014259
R9378 VSS.n1102 VSS.n212 0.014259
R9379 VSS.n1102 VSS.n208 0.014259
R9380 VSS.n1106 VSS.n208 0.014259
R9381 VSS.n905 VSS.n196 0.01425
R9382 VSS.n1287 VSS.n1217 0.01425
R9383 VSS.n1997 VSS.n74 0.0142083
R9384 VSS.n683 VSS.n682 0.0141084
R9385 VSS.n688 VSS.n687 0.0141084
R9386 VSS.n1997 VSS.n104 0.0132497
R9387 VSS.n324 VSS.n322 0.012944
R9388 VSS.n970 VSS.n969 0.01216
R9389 VSS.n2021 VSS.n2020 0.01216
R9390 VSS.n1625 VSS.n1624 0.01106
R9391 VSS.n1626 VSS.n1625 0.01106
R9392 VSS.n1627 VSS.n1626 0.01106
R9393 VSS.n1629 VSS.n1627 0.01106
R9394 VSS.n1630 VSS.n1629 0.01106
R9395 VSS.n1460 VSS.n1454 0.01106
R9396 VSS.n1488 VSS.n1454 0.01106
R9397 VSS.n1489 VSS.n1488 0.01106
R9398 VSS.n1490 VSS.n1489 0.01106
R9399 VSS.n1491 VSS.n1490 0.01106
R9400 VSS.n948 VSS.n947 0.01106
R9401 VSS.n948 VSS.n940 0.01106
R9402 VSS.n959 VSS.n940 0.01106
R9403 VSS.n960 VSS.n959 0.01106
R9404 VSS.n961 VSS.n960 0.01106
R9405 VSS.n961 VSS.n934 0.01106
R9406 VSS.n969 VSS.n934 0.01106
R9407 VSS.n971 VSS.n970 0.01106
R9408 VSS.n2020 VSS.n15 0.01106
R9409 VSS.n2023 VSS.n2021 0.01106
R9410 VSS.n2023 VSS.n2022 0.01106
R9411 VSS.n2022 VSS.n9 0.01106
R9412 VSS.n2032 VSS.n9 0.01106
R9413 VSS.n2033 VSS.n2032 0.01106
R9414 VSS.n2034 VSS.n2033 0.01106
R9415 VSS.n2035 VSS.n2034 0.01106
R9416 VSS.n328 VSS.n325 0.0106068
R9417 VSS.n987 VSS.n986 0.0104431
R9418 VSS.n988 VSS.n987 0.0104431
R9419 VSS.n1976 VSS.n1126 0.0104431
R9420 VSS.n1976 VSS.n1975 0.0104431
R9421 VSS.n1975 VSS.n1127 0.0104431
R9422 VSS.n1942 VSS.n1127 0.0104431
R9423 VSS.n1942 VSS.n1941 0.0104431
R9424 VSS.n1908 VSS.n1186 0.0104431
R9425 VSS.n1908 VSS.n1907 0.0104431
R9426 VSS.n1907 VSS.n1187 0.0104431
R9427 VSS.n1874 VSS.n1187 0.0104431
R9428 VSS.n1874 VSS.n1873 0.0104431
R9429 VSS.n1840 VSS.n1839 0.0104431
R9430 VSS.n1840 VSS.n0 0.0104431
R9431 VSS.n2044 VSS.n0 0.0104431
R9432 VSS.n184 VSS.n174 0.00996
R9433 VSS.n1425 VSS.n1392 0.00996
R9434 VSS.n174 VSS.n124 0.00953158
R9435 VSS.n185 VSS.n123 0.00953158
R9436 VSS.n1392 VSS.n1342 0.00953158
R9437 VSS.n1426 VSS.n1341 0.00953158
R9438 VSS.n697 VSS 0.0095
R9439 VSS.n187 VSS.n120 0.00938217
R9440 VSS.n1873 VSS.n1217 0.00848519
R9441 VSS.n1126 VSS.n196 0.00847494
R9442 VSS.n186 VSS.n120 0.00845925
R9443 VSS.n1496 VSS.n1495 0.00815846
R9444 VSS.n1513 VSS.n1511 0.00815846
R9445 VSS.n1599 VSS.n1598 0.00815846
R9446 VSS.n1620 VSS.n1619 0.00815846
R9447 VSS.n186 VSS.n117 0.00811343
R9448 VSS.n1675 VSS.n1674 0.00781809
R9449 VSS.n1810 VSS.n1258 0.00781809
R9450 VSS.n861 VSS.n860 0.00781809
R9451 VSS.n1105 VSS.n209 0.00781809
R9452 VSS.n1631 VSS.n1630 0.00777128
R9453 VSS.n1624 VSS.n1622 0.00751146
R9454 VSS.n1493 VSS.n1491 0.00751146
R9455 VSS.n1500 VSS.n1498 0.00743596
R9456 VSS.n1501 VSS.n1500 0.00743596
R9457 VSS.n1504 VSS.n1503 0.00743596
R9458 VSS.n1508 VSS.n1507 0.00743596
R9459 VSS.n1511 VSS.n1510 0.00743596
R9460 VSS.n1516 VSS.n1515 0.00743596
R9461 VSS.n1519 VSS.n1518 0.00743596
R9462 VSS.n1523 VSS.n1519 0.00743596
R9463 VSS.n1527 VSS.n1525 0.00743596
R9464 VSS.n1535 VSS.n1448 0.00743596
R9465 VSS.n1540 VSS.n1537 0.00743596
R9466 VSS.n1540 VSS.n1539 0.00743596
R9467 VSS.n1549 VSS.n1442 0.00743596
R9468 VSS.n1552 VSS.n1551 0.00743596
R9469 VSS.n1553 VSS.n1552 0.00743596
R9470 VSS.n1557 VSS.n1556 0.00743596
R9471 VSS.n1560 VSS.n1559 0.00743596
R9472 VSS.n1564 VSS.n1563 0.00743596
R9473 VSS.n1565 VSS.n1564 0.00743596
R9474 VSS.n1569 VSS.n1567 0.00743596
R9475 VSS.n1572 VSS.n1571 0.00743596
R9476 VSS.n1573 VSS.n1572 0.00743596
R9477 VSS.n1577 VSS.n1576 0.00743596
R9478 VSS.n1580 VSS.n1579 0.00743596
R9479 VSS.n1586 VSS.n1582 0.00743596
R9480 VSS.n1587 VSS.n1586 0.00743596
R9481 VSS.n1590 VSS.n1589 0.00743596
R9482 VSS.n1602 VSS.n1601 0.00743596
R9483 VSS.n1601 VSS.n1431 0.00743596
R9484 VSS.n1612 VSS.n1611 0.00743596
R9485 VSS.n1615 VSS.n1614 0.00743596
R9486 VSS.n1617 VSS.n1615 0.00743596
R9487 VSS.n1576 VSS.n1574 0.00736371
R9488 VSS.n1600 VSS.n1599 0.00736371
R9489 VSS.n181 VSS.n175 0.00722858
R9490 VSS.n1556 VSS.n1554 0.00721921
R9491 VSS.n971 VSS.n928 0.00717333
R9492 VSS.n2012 VSS.n15 0.00717333
R9493 VSS.n1525 VSS.n1524 0.00707471
R9494 VSS.n1678 VSS.n1676 0.00699846
R9495 VSS.n1678 VSS.n1677 0.00699846
R9496 VSS.n1677 VSS.n1308 0.00699846
R9497 VSS.n1701 VSS.n1308 0.00699846
R9498 VSS.n1702 VSS.n1701 0.00699846
R9499 VSS.n1703 VSS.n1702 0.00699846
R9500 VSS.n1703 VSS.n1296 0.00699846
R9501 VSS.n1722 VSS.n1296 0.00699846
R9502 VSS.n1723 VSS.n1722 0.00699846
R9503 VSS.n1725 VSS.n1723 0.00699846
R9504 VSS.n1725 VSS.n1724 0.00699846
R9505 VSS.n1724 VSS.n1289 0.00699846
R9506 VSS.n1747 VSS.n1746 0.00699846
R9507 VSS.n1748 VSS.n1747 0.00699846
R9508 VSS.n1748 VSS.n1276 0.00699846
R9509 VSS.n1768 VSS.n1276 0.00699846
R9510 VSS.n1769 VSS.n1768 0.00699846
R9511 VSS.n1770 VSS.n1769 0.00699846
R9512 VSS.n1770 VSS.n1267 0.00699846
R9513 VSS.n1788 VSS.n1267 0.00699846
R9514 VSS.n1789 VSS.n1788 0.00699846
R9515 VSS.n1790 VSS.n1789 0.00699846
R9516 VSS.n1790 VSS.n1259 0.00699846
R9517 VSS.n1809 VSS.n1259 0.00699846
R9518 VSS.n863 VSS.n862 0.00699846
R9519 VSS.n863 VSS.n821 0.00699846
R9520 VSS.n881 VSS.n821 0.00699846
R9521 VSS.n882 VSS.n881 0.00699846
R9522 VSS.n883 VSS.n882 0.00699846
R9523 VSS.n883 VSS.n810 0.00699846
R9524 VSS.n899 VSS.n810 0.00699846
R9525 VSS.n900 VSS.n899 0.00699846
R9526 VSS.n901 VSS.n900 0.00699846
R9527 VSS.n902 VSS.n901 0.00699846
R9528 VSS.n903 VSS.n902 0.00699846
R9529 VSS.n906 VSS.n903 0.00699846
R9530 VSS.n904 VSS.n237 0.00699846
R9531 VSS.n1041 VSS.n237 0.00699846
R9532 VSS.n1042 VSS.n1041 0.00699846
R9533 VSS.n1043 VSS.n1042 0.00699846
R9534 VSS.n1044 VSS.n1043 0.00699846
R9535 VSS.n1045 VSS.n1044 0.00699846
R9536 VSS.n1045 VSS.n219 0.00699846
R9537 VSS.n1083 VSS.n219 0.00699846
R9538 VSS.n1084 VSS.n1083 0.00699846
R9539 VSS.n1085 VSS.n1084 0.00699846
R9540 VSS.n1085 VSS.n210 0.00699846
R9541 VSS.n1104 VSS.n210 0.00699846
R9542 VSS.n1503 VSS.n1502 0.00693021
R9543 VSS.n1509 VSS.n1508 0.00678571
R9544 VSS.n1536 VSS.n1535 0.00664122
R9545 VSS.n837 VSS.n836 0.00661111
R9546 VSS.n849 VSS.n838 0.00661111
R9547 VSS.n838 VSS.n835 0.00661111
R9548 VSS.n853 VSS.n826 0.00661111
R9549 VSS.n869 VSS.n825 0.00661111
R9550 VSS.n873 VSS.n816 0.00661111
R9551 VSS.n889 VSS.n815 0.00661111
R9552 VSS.n893 VSS.n815 0.00661111
R9553 VSS.n915 VSS.n806 0.00661111
R9554 VSS.n919 VSS.n917 0.00661111
R9555 VSS.n1026 VSS.n253 0.00661111
R9556 VSS.n256 VSS.n255 0.00661111
R9557 VSS.n255 VSS.n254 0.00661111
R9558 VSS.n1061 VSS.n1060 0.00661111
R9559 VSS.n1050 VSS.n1049 0.00661111
R9560 VSS.n1077 VSS.n1076 0.00661111
R9561 VSS.n1092 VSS.n215 0.00661111
R9562 VSS.n1093 VSS.n1092 0.00661111
R9563 VSS.n1098 VSS.n1097 0.00661111
R9564 VSS.n1110 VSS.n1109 0.00661111
R9565 VSS.n1985 VSS.n1984 0.00661111
R9566 VSS.n1637 VSS.n1636 0.00661111
R9567 VSS.n1644 VSS.n1340 0.00661111
R9568 VSS.n1645 VSS.n1644 0.00661111
R9569 VSS.n1651 VSS.n1650 0.00661111
R9570 VSS.n1655 VSS.n1654 0.00661111
R9571 VSS.n1670 VSS.n1669 0.00661111
R9572 VSS.n1323 VSS.n1319 0.00661111
R9573 VSS.n1323 VSS.n1322 0.00661111
R9574 VSS.n1695 VSS.n1694 0.00661111
R9575 VSS.n1711 VSS.n1710 0.00661111
R9576 VSS.n1717 VSS.n1716 0.00661111
R9577 VSS.n1731 VSS.n1292 0.00661111
R9578 VSS.n1732 VSS.n1731 0.00661111
R9579 VSS.n1740 VSS.n1739 0.00661111
R9580 VSS.n1756 VSS.n1755 0.00661111
R9581 VSS.n1763 VSS.n1762 0.00661111
R9582 VSS.n1776 VSS.n1272 0.00661111
R9583 VSS.n1777 VSS.n1776 0.00661111
R9584 VSS.n1782 VSS.n1781 0.00661111
R9585 VSS.n1798 VSS.n1797 0.00661111
R9586 VSS.n1803 VSS.n1802 0.00661111
R9587 VSS.n1818 VSS.n1255 0.00661111
R9588 VSS.n1819 VSS.n1818 0.00661111
R9589 VSS.n1824 VSS.n1823 0.00661111
R9590 VSS.n1561 VSS.n1560 0.00649672
R9591 VSS.n1581 VSS.n1580 0.00635222
R9592 VSS.n187 VSS.n121 0.00632661
R9593 VSS.n1461 VSS.n1460 0.00622
R9594 VSS.n1613 VSS.n1612 0.00620772
R9595 VSS.n1992 VSS.n1988 0.00608366
R9596 VSS.n1538 VSS.n1442 0.00606322
R9597 VSS.n1515 VSS.n1514 0.00591872
R9598 VSS.n103 VSS.n30 0.00591841
R9599 VSS.n850 VSS.n837 0.00584722
R9600 VSS.n853 VSS.n852 0.00584722
R9601 VSS.n890 VSS.n816 0.00584722
R9602 VSS.n892 VSS.n806 0.00584722
R9603 VSS.n1026 VSS.n1025 0.00584722
R9604 VSS.n1060 VSS.n231 0.00584722
R9605 VSS.n1077 VSS.n111 0.00584722
R9606 VSS.n1098 VSS.n113 0.00584722
R9607 VSS.n1985 VSS.n117 0.00584722
R9608 VSS.n1637 VSS.n32 0.00584722
R9609 VSS.n1650 VSS.n69 0.00584722
R9610 VSS.n1670 VSS.n36 0.00584722
R9611 VSS.n1695 VSS.n66 0.00584722
R9612 VSS.n1717 VSS.n40 0.00584722
R9613 VSS.n1740 VSS.n63 0.00584722
R9614 VSS.n1763 VSS.n44 0.00584722
R9615 VSS.n1782 VSS.n60 0.00584722
R9616 VSS.n1802 VSS.n48 0.00584722
R9617 VSS.n1823 VSS.n58 0.00584722
R9618 VSS.n1619 VSS.n1618 0.00577422
R9619 VSS.n751 VSS.n750 0.00571224
R9620 VSS.n754 VSS.n751 0.00571224
R9621 VSS.n727 VSS.n719 0.00571224
R9622 VSS.n727 VSS.n726 0.00571224
R9623 VSS.n769 VSS.n276 0.00565931
R9624 VSS.n1590 VSS.n1588 0.00562972
R9625 VSS.n1567 VSS.n1566 0.00548522
R9626 VSS.n1941 VSS 0.00542027
R9627 VSS.n1186 VSS 0.00542027
R9628 VSS.n1570 VSS.n1569 0.00534072
R9629 VSS.n719 VSS.n718 0.00526701
R9630 VSS.n750 VSS.n320 0.00522929
R9631 VSS.n1589 VSS.n1436 0.00519622
R9632 VSS.n1495 VSS.n1494 0.00505172
R9633 VSS.n1497 VSS.n1496 0.00505172
R9634 VSS.n1517 VSS.n1516 0.00490723
R9635 VSS.n1550 VSS.n1549 0.00476273
R9636 VSS.n747 VSS.n746 0.00466979
R9637 VSS.n747 VSS.n734 0.00466979
R9638 VSS.n757 VSS.n734 0.00466979
R9639 VSS.n757 VSS.n736 0.00466979
R9640 VSS.n744 VSS.n742 0.00466979
R9641 VSS.n748 VSS.n742 0.00466979
R9642 VSS.n748 VSS.n737 0.00466979
R9643 VSS.n756 VSS.n737 0.00466979
R9644 VSS.n756 VSS.n738 0.00466979
R9645 VSS.n752 VSS.n738 0.00466979
R9646 VSS.n743 VSS.n741 0.00466979
R9647 VSS.n749 VSS.n741 0.00466979
R9648 VSS.n749 VSS.n739 0.00466979
R9649 VSS.n755 VSS.n739 0.00466979
R9650 VSS.n755 VSS.n740 0.00466979
R9651 VSS.n715 VSS.n470 0.00466979
R9652 VSS.n730 VSS.n470 0.00466979
R9653 VSS.n730 VSS.n471 0.00466979
R9654 VSS.n722 VSS.n471 0.00466979
R9655 VSS.n716 VSS.n713 0.00466979
R9656 VSS.n716 VSS.n472 0.00466979
R9657 VSS.n729 VSS.n472 0.00466979
R9658 VSS.n729 VSS.n473 0.00466979
R9659 VSS.n723 VSS.n473 0.00466979
R9660 VSS.n723 VSS.n720 0.00466979
R9661 VSS.n717 VSS.n712 0.00466979
R9662 VSS.n717 VSS.n474 0.00466979
R9663 VSS.n728 VSS.n474 0.00466979
R9664 VSS.n728 VSS.n475 0.00466979
R9665 VSS.n724 VSS.n475 0.00466979
R9666 VSS.n1611 VSS.n1429 0.00461823
R9667 VSS.n1394 VSS.n1393 0.00455515
R9668 VSS.n1579 VSS.n1578 0.00447373
R9669 VSS.n441 VSS.n440 0.00435637
R9670 VSS.n1559 VSS.n1558 0.00432923
R9671 VSS.n1621 VSS.n1620 0.00432923
R9672 VSS.n1020 VSS.n775 0.00431944
R9673 VSS.n870 VSS.n869 0.00431944
R9674 VSS.n872 VSS.n825 0.00431944
R9675 VSS.n917 VSS.n916 0.00431944
R9676 VSS.n919 VSS.n918 0.00431944
R9677 VSS.n1050 VSS.n108 0.00431944
R9678 VSS.n1049 VSS.n110 0.00431944
R9679 VSS.n1110 VSS.n114 0.00431944
R9680 VSS.n1109 VSS.n116 0.00431944
R9681 VSS.n1987 VSS.n121 0.00431944
R9682 VSS.n1633 VSS.n70 0.00431944
R9683 VSS.n1655 VSS.n34 0.00431944
R9684 VSS.n1654 VSS.n68 0.00431944
R9685 VSS.n1710 VSS.n38 0.00431944
R9686 VSS.n1711 VSS.n65 0.00431944
R9687 VSS.n1755 VSS.n42 0.00431944
R9688 VSS.n1756 VSS.n62 0.00431944
R9689 VSS.n1797 VSS.n46 0.00431944
R9690 VSS.n1798 VSS.n59 0.00431944
R9691 VSS.n1999 VSS.n28 0.00431944
R9692 VSS.n1526 VSS.n1448 0.00418473
R9693 VSS.n1507 VSS.n1505 0.00404023
R9694 VSS.n759 VSS.n733 0.00391195
R9695 VSS.n759 VSS.n758 0.00391195
R9696 VSS.n731 VSS.n468 0.00391195
R9697 VSS.n731 VSS.n469 0.00391195
R9698 VSS.n1505 VSS.n1504 0.00389573
R9699 VSS.n979 VSS.n928 0.00388462
R9700 VSS.n980 VSS.n979 0.00388462
R9701 VSS.n981 VSS.n980 0.00388462
R9702 VSS.n981 VSS.n776 0.00388462
R9703 VSS.n1632 VSS.n1631 0.00388462
R9704 VSS.n1635 VSS.n1634 0.00388462
R9705 VSS.n2001 VSS.n21 0.00388462
R9706 VSS.n2010 VSS.n21 0.00388462
R9707 VSS.n2011 VSS.n2010 0.00388462
R9708 VSS.n2012 VSS.n2011 0.00388462
R9709 VSS.n718 VSS.n586 0.00382633
R9710 VSS.n766 VSS.n320 0.00376369
R9711 VSS.n1527 VSS.n1526 0.00375123
R9712 VSS.n1289 VSS.n1287 0.00374923
R9713 VSS.n1746 VSS.n1287 0.00374923
R9714 VSS.n906 VSS.n905 0.00374923
R9715 VSS.n905 VSS.n904 0.00374923
R9716 VSS.n1111 VSS.n1108 0.00374359
R9717 VSS.n1982 VSS.n189 0.00374359
R9718 VSS.n1638 VSS.n1428 0.00374359
R9719 VSS.n1643 VSS.n1642 0.00374359
R9720 VSS.n1646 VSS.n1339 0.00374359
R9721 VSS.n1649 VSS.n1648 0.00374359
R9722 VSS.n1652 VSS.n1338 0.00374359
R9723 VSS.n1657 VSS.n1656 0.00374359
R9724 VSS.n1653 VSS.n1331 0.00374359
R9725 VSS.n1558 VSS.n1557 0.00360673
R9726 VSS.n1622 VSS.n1621 0.00360673
R9727 VSS.n1021 VSS.n774 0.00356734
R9728 VSS.n1578 VSS.n1577 0.00346223
R9729 VSS.n440 VSS.n439 0.00343313
R9730 VSS.n1431 VSS.n1429 0.00331773
R9731 VSS.n1551 VSS.n1550 0.00317323
R9732 VSS.n736 VSS.n735 0.00306317
R9733 VSS.n746 VSS.n745 0.00306317
R9734 VSS.n722 VSS.n721 0.00306317
R9735 VSS.n715 VSS.n714 0.00306317
R9736 VSS.n753 VSS.n740 0.00305808
R9737 VSS.n725 VSS.n724 0.00305808
R9738 VSS.n818 VSS.n814 0.00303846
R9739 VSS.n896 VSS.n894 0.00303846
R9740 VSS.n895 VSS.n807 0.00303846
R9741 VSS.n914 VSS.n913 0.00303846
R9742 VSS.n921 VSS.n803 0.00303846
R9743 VSS.n920 VSS.n805 0.00303846
R9744 VSS.n1028 VSS.n250 0.00303846
R9745 VSS.n1027 VSS.n252 0.00303846
R9746 VSS.n1037 VSS.n240 0.00303846
R9747 VSS.n243 VSS.n241 0.00303846
R9748 VSS.n1057 VSS.n232 0.00303846
R9749 VSS.n1059 VSS.n229 0.00303846
R9750 VSS.n1062 VSS.n230 0.00303846
R9751 VSS.n1052 VSS.n1051 0.00303846
R9752 VSS.n1048 VSS.n222 0.00303846
R9753 VSS.n1080 VSS.n1073 0.00303846
R9754 VSS.n1078 VSS.n1075 0.00303846
R9755 VSS.n1088 VSS.n216 0.00303846
R9756 VSS.n1091 VSS.n1090 0.00303846
R9757 VSS.n1101 VSS.n1094 0.00303846
R9758 VSS.n1099 VSS.n1096 0.00303846
R9759 VSS.n1107 VSS.n207 0.00303846
R9760 VSS.n1518 VSS.n1517 0.00302874
R9761 VSS.n1668 VSS.n1667 0.00300321
R9762 VSS.n1672 VSS.n1671 0.00300321
R9763 VSS.n1329 VSS.n1317 0.00300321
R9764 VSS.n1681 VSS.n1324 0.00300321
R9765 VSS.n1321 VSS.n1320 0.00300321
R9766 VSS.n1697 VSS.n1696 0.00300321
R9767 VSS.n1693 VSS.n1692 0.00300321
R9768 VSS.n1709 VSS.n1707 0.00300321
R9769 VSS.n1712 VSS.n1304 0.00300321
R9770 VSS.n1715 VSS.n1714 0.00300321
R9771 VSS.n1719 VSS.n1718 0.00300321
R9772 VSS.n1302 VSS.n1301 0.00300321
R9773 VSS.n1730 VSS.n1728 0.00300321
R9774 VSS.n1733 VSS.n1291 0.00300321
R9775 VSS.n1742 VSS.n1741 0.00300321
R9776 VSS.n1738 VSS.n1737 0.00300321
R9777 VSS.n1754 VSS.n1752 0.00300321
R9778 VSS.n1757 VSS.n1283 0.00300321
R9779 VSS.n1761 VSS.n1760 0.00300321
R9780 VSS.n1765 VSS.n1764 0.00300321
R9781 VSS.n1281 VSS.n1280 0.00300321
R9782 VSS.n1775 VSS.n1773 0.00300321
R9783 VSS.n1494 VSS.n1493 0.00288424
R9784 VSS.n1498 VSS.n1497 0.00288424
R9785 VSS.n836 VSS.n775 0.00279167
R9786 VSS.n870 VSS.n826 0.00279167
R9787 VSS.n873 VSS.n872 0.00279167
R9788 VSS.n916 VSS.n915 0.00279167
R9789 VSS.n918 VSS.n253 0.00279167
R9790 VSS.n1061 VSS.n108 0.00279167
R9791 VSS.n1076 VSS.n110 0.00279167
R9792 VSS.n1097 VSS.n114 0.00279167
R9793 VSS.n1984 VSS.n116 0.00279167
R9794 VSS.n1636 VSS.n70 0.00279167
R9795 VSS.n1651 VSS.n34 0.00279167
R9796 VSS.n1669 VSS.n68 0.00279167
R9797 VSS.n1694 VSS.n38 0.00279167
R9798 VSS.n1716 VSS.n65 0.00279167
R9799 VSS.n1739 VSS.n42 0.00279167
R9800 VSS.n1762 VSS.n62 0.00279167
R9801 VSS.n1781 VSS.n46 0.00279167
R9802 VSS.n1803 VSS.n59 0.00279167
R9803 VSS.n1824 VSS.n28 0.00279167
R9804 VSS.n1598 VSS.n1436 0.00273974
R9805 VSS.n848 VSS.n847 0.0026859
R9806 VSS.n846 VSS.n845 0.0026859
R9807 VSS.n844 VSS.n843 0.0026859
R9808 VSS.n855 VSS.n854 0.0026859
R9809 VSS.n857 VSS.n856 0.0026859
R9810 VSS.n868 VSS.n867 0.0026859
R9811 VSS.n830 VSS.n829 0.0026859
R9812 VSS.n875 VSS.n874 0.0026859
R9813 VSS.n877 VSS.n876 0.0026859
R9814 VSS.n888 VSS.n887 0.0026859
R9815 VSS.n1778 VSS.n1271 0.0026859
R9816 VSS.n1784 VSS.n1783 0.0026859
R9817 VSS.n1779 VSS.n1264 0.0026859
R9818 VSS.n1796 VSS.n1794 0.0026859
R9819 VSS.n1799 VSS.n1263 0.0026859
R9820 VSS.n1805 VSS.n1804 0.0026859
R9821 VSS.n1800 VSS.n1256 0.0026859
R9822 VSS.n1814 VSS.n1813 0.0026859
R9823 VSS.n1817 VSS.n1816 0.0026859
R9824 VSS.n1820 VSS.n1254 0.0026859
R9825 VSS.n1571 VSS.n1570 0.00259524
R9826 VSS.n1640 VSS.n1639 0.00254487
R9827 VSS.n988 VSS.n196 0.00246811
R9828 VSS.n1839 VSS.n1217 0.00245786
R9829 VSS.n1566 VSS.n1565 0.00245074
R9830 VSS.n1019 VSS.n1018 0.00233333
R9831 VSS.n839 VSS.n777 0.00233333
R9832 VSS.n841 VSS.n840 0.00233333
R9833 VSS.n1822 VSS.n1821 0.00233333
R9834 VSS.n1826 VSS.n1825 0.00233333
R9835 VSS.n2000 VSS.n27 0.00233333
R9836 VSS.n1588 VSS.n1587 0.00230624
R9837 VSS.n583 VSS.n476 0.00222066
R9838 VSS VSS.n2044 0.00218109
R9839 VSS.n1618 VSS.n1617 0.00216174
R9840 VSS.n1019 VSS.n776 0.00205128
R9841 VSS.n1018 VSS.n777 0.00205128
R9842 VSS.n840 VSS.n839 0.00205128
R9843 VSS.n848 VSS.n841 0.00205128
R9844 VSS.n1821 VSS.n1820 0.00205128
R9845 VSS.n1826 VSS.n1822 0.00205128
R9846 VSS.n1825 VSS.n27 0.00205128
R9847 VSS.n2001 VSS.n2000 0.00205128
R9848 VSS.n1514 VSS.n1513 0.00201724
R9849 VSS.n1537 VSS.n1536 0.00201724
R9850 VSS.n538 VSS.n485 0.00194116
R9851 VSS.n1539 VSS.n1538 0.00187274
R9852 VSS.n1614 VSS.n1613 0.00172824
R9853 VSS.n847 VSS.n846 0.00169872
R9854 VSS.n845 VSS.n844 0.00169872
R9855 VSS.n1641 VSS.n1640 0.00169872
R9856 VSS.n1816 VSS.n1814 0.00169872
R9857 VSS.n1817 VSS.n1254 0.00169872
R9858 VSS.n526 VSS.n502 0.00166667
R9859 VSS.n444 VSS.n390 0.00166667
R9860 VSS.n543 VSS.n479 0.00166667
R9861 VSS.n530 VSS.n501 0.00166667
R9862 VSS.n180 VSS.n179 0.00166667
R9863 VSS.n177 VSS.n119 0.00166667
R9864 VSS.n1411 VSS.n31 0.00166667
R9865 VSS.n307 VSS.n271 0.00166667
R9866 VSS.n1024 VSS.n109 0.00166667
R9867 VSS.n1993 VSS.n72 0.00166667
R9868 VSS.n766 VSS.n319 0.00164919
R9869 VSS.n711 VSS.n586 0.00160878
R9870 VSS.n1582 VSS.n1581 0.00158374
R9871 VSS.n1992 VSS.n1991 0.00151852
R9872 VSS.n770 VSS.n769 0.00146948
R9873 VSS.n1563 VSS.n1561 0.00143924
R9874 VSS.n1775 VSS.n1774 0.00138141
R9875 VSS.n1785 VSS.n1778 0.00138141
R9876 VSS.n1783 VSS.n1780 0.00138141
R9877 VSS.n1793 VSS.n1264 0.00138141
R9878 VSS.n1796 VSS.n1795 0.00138141
R9879 VSS.n1806 VSS.n1799 0.00138141
R9880 VSS.n1804 VSS.n1801 0.00138141
R9881 VSS.n1812 VSS.n1256 0.00138141
R9882 VSS.n854 VSS.n834 0.00134615
R9883 VSS.n858 VSS.n857 0.00134615
R9884 VSS.n868 VSS.n827 0.00134615
R9885 VSS.n866 VSS.n830 0.00134615
R9886 VSS.n874 VSS.n824 0.00134615
R9887 VSS.n878 VSS.n877 0.00134615
R9888 VSS.n888 VSS.n817 0.00134615
R9889 VSS.n886 VSS.n818 0.00134615
R9890 VSS.n894 VSS.n814 0.00134615
R9891 VSS.n896 VSS.n895 0.00134615
R9892 VSS.n914 VSS.n807 0.00134615
R9893 VSS.n913 VSS.n803 0.00134615
R9894 VSS.n921 VSS.n920 0.00134615
R9895 VSS.n805 VSS.n250 0.00134615
R9896 VSS.n1028 VSS.n1027 0.00134615
R9897 VSS.n252 VSS.n240 0.00134615
R9898 VSS.n1037 VSS.n241 0.00134615
R9899 VSS.n243 VSS.n232 0.00134615
R9900 VSS.n1301 VSS.n1293 0.00134615
R9901 VSS.n1730 VSS.n1729 0.00134615
R9902 VSS.n1735 VSS.n1733 0.00134615
R9903 VSS.n1741 VSS.n1736 0.00134615
R9904 VSS.n1738 VSS.n1284 0.00134615
R9905 VSS.n1754 VSS.n1753 0.00134615
R9906 VSS.n1759 VSS.n1757 0.00134615
R9907 VSS.n1761 VSS.n1279 0.00134615
R9908 VSS.n1764 VSS.n1282 0.00134615
R9909 VSS.n1280 VSS.n1273 0.00134615
R9910 VSS.n769 VSS.n271 0.00133332
R9911 VSS.n530 VSS.n529 0.00133332
R9912 VSS.n583 VSS.n479 0.00133332
R9913 VSS.n454 VSS.n390 0.00133332
R9914 VSS.n529 VSS.n502 0.00133332
R9915 VSS.n1997 VSS.n72 0.00133332
R9916 VSS.n181 VSS.n180 0.00133332
R9917 VSS.n1997 VSS.n119 0.00133332
R9918 VSS.n1997 VSS.n109 0.00133332
R9919 VSS.n1997 VSS.n31 0.00133332
R9920 VSS.n769 VSS.n277 0.00130912
R9921 VSS.n1574 VSS.n1573 0.00129475
R9922 VSS.n850 VSS.n849 0.00126389
R9923 VSS.n852 VSS.n835 0.00126389
R9924 VSS.n890 VSS.n889 0.00126389
R9925 VSS.n893 VSS.n892 0.00126389
R9926 VSS.n1025 VSS.n256 0.00126389
R9927 VSS.n254 VSS.n231 0.00126389
R9928 VSS.n215 VSS.n111 0.00126389
R9929 VSS.n1093 VSS.n113 0.00126389
R9930 VSS.n1340 VSS.n32 0.00126389
R9931 VSS.n1645 VSS.n69 0.00126389
R9932 VSS.n1319 VSS.n36 0.00126389
R9933 VSS.n1322 VSS.n66 0.00126389
R9934 VSS.n1292 VSS.n40 0.00126389
R9935 VSS.n1732 VSS.n63 0.00126389
R9936 VSS.n1272 VSS.n44 0.00126389
R9937 VSS.n1777 VSS.n60 0.00126389
R9938 VSS.n1255 VSS.n48 0.00126389
R9939 VSS.n1819 VSS.n58 0.00126389
R9940 VSS.n1667 VSS.n1666 0.00124039
R9941 VSS.n1672 VSS.n1328 0.00124039
R9942 VSS.n769 VSS.n302 0.00122263
R9943 VSS.n1096 VSS.n1095 0.00120513
R9944 VSS.n1112 VSS.n1107 0.00120513
R9945 VSS.n1510 VSS.n1509 0.00115025
R9946 VSS.n1983 VSS.n188 0.00113461
R9947 VSS.n560 VSS.n483 0.00109542
R9948 VSS.n560 VSS.n485 0.00105882
R9949 VSS.n709 VSS.n600 0.0010228
R9950 VSS.n769 VSS.n297 0.00102161
R9951 VSS.n769 VSS.n768 0.00101819
R9952 VSS.n1502 VSS.n1501 0.00100575
R9953 VSS.n769 VSS.n298 0.00100339
R9954 VSS.n560 VSS.n488 0.00100322
R9955 VSS.n769 VSS.n281 0.00100063
R9956 VSS.n769 VSS.n299 0.00100055
R9957 VSS.n769 VSS.n280 0.00100013
R9958 VSS.n709 VSS.n641 0.00100005
R9959 VSS.n307 VSS.n266 0.001
R9960 VSS.n309 VSS.n267 0.001
R9961 VSS.n311 VSS.n268 0.001
R9962 VSS.n313 VSS.n269 0.001
R9963 VSS.n315 VSS.n270 0.001
R9964 VSS.n560 VSS.n487 0.001
R9965 VSS.n519 VSS.n518 0.001
R9966 VSS.n523 VSS.n522 0.001
R9967 VSS.n525 VSS.n517 0.001
R9968 VSS.n501 VSS.n495 0.001
R9969 VSS.n503 VSS.n496 0.001
R9970 VSS.n504 VSS.n497 0.001
R9971 VSS.n505 VSS.n498 0.001
R9972 VSS.n506 VSS.n499 0.001
R9973 VSS.n507 VSS.n500 0.001
R9974 VSS.n508 VSS.n494 0.001
R9975 VSS.n543 VSS.n539 0.001
R9976 VSS.n545 VSS.n540 0.001
R9977 VSS.n547 VSS.n541 0.001
R9978 VSS.n549 VSS.n542 0.001
R9979 VSS.n554 VSS.n552 0.001
R9980 VSS.n553 VSS.n481 0.001
R9981 VSS.n440 VSS.n395 0.001
R9982 VSS.n435 VSS.n434 0.001
R9983 VSS.n417 VSS.n404 0.001
R9984 VSS.n425 VSS.n418 0.001
R9985 VSS.n424 VSS.n419 0.001
R9986 VSS.n423 VSS.n420 0.001
R9987 VSS.n422 VSS.n421 0.001
R9988 VSS.n432 VSS.n431 0.001
R9989 VSS.n440 VSS.n393 0.001
R9990 VSS.n437 VSS.n394 0.001
R9991 VSS.n443 VSS.n392 0.001
R9992 VSS.n455 VSS.n389 0.001
R9993 VSS.n389 VSS.n383 0.001
R9994 VSS.n446 VSS.n384 0.001
R9995 VSS.n447 VSS.n385 0.001
R9996 VSS.n448 VSS.n387 0.001
R9997 VSS.n386 VSS.n327 0.001
R9998 VSS.n458 VSS.n457 0.001
R9999 VSS.n432 VSS.n328 0.001
R10000 VSS.n431 VSS.n421 0.001
R10001 VSS.n422 VSS.n420 0.001
R10002 VSS.n423 VSS.n419 0.001
R10003 VSS.n424 VSS.n418 0.001
R10004 VSS.n425 VSS.n417 0.001
R10005 VSS.n434 VSS.n404 0.001
R10006 VSS.n435 VSS.n395 0.001
R10007 VSS.n437 VSS.n393 0.001
R10008 VSS.n394 VSS.n392 0.001
R10009 VSS.n444 VSS.n443 0.001
R10010 VSS.n455 VSS.n454 0.001
R10011 VSS.n446 VSS.n383 0.001
R10012 VSS.n447 VSS.n384 0.001
R10013 VSS.n448 VSS.n385 0.001
R10014 VSS.n387 VSS.n386 0.001
R10015 VSS.n458 VSS.n327 0.001
R10016 VSS.n457 VSS.n328 0.001
R10017 VSS.n331 VSS.n322 0.001
R10018 VSS.n342 VSS.n332 0.001
R10019 VSS.n344 VSS.n333 0.001
R10020 VSS.n346 VSS.n334 0.001
R10021 VSS.n348 VSS.n335 0.001
R10022 VSS.n350 VSS.n336 0.001
R10023 VSS.n352 VSS.n337 0.001
R10024 VSS.n354 VSS.n338 0.001
R10025 VSS.n356 VSS.n339 0.001
R10026 VSS.n358 VSS.n340 0.001
R10027 VSS.n360 VSS.n341 0.001
R10028 VSS.n364 VSS.n363 0.001
R10029 VSS.n366 VSS.n365 0.001
R10030 VSS.n545 VSS.n539 0.001
R10031 VSS.n547 VSS.n540 0.001
R10032 VSS.n549 VSS.n541 0.001
R10033 VSS.n552 VSS.n542 0.001
R10034 VSS.n554 VSS.n553 0.001
R10035 VSS.n583 VSS.n481 0.001
R10036 VSS.n503 VSS.n495 0.001
R10037 VSS.n504 VSS.n496 0.001
R10038 VSS.n505 VSS.n497 0.001
R10039 VSS.n506 VSS.n498 0.001
R10040 VSS.n507 VSS.n499 0.001
R10041 VSS.n508 VSS.n500 0.001
R10042 VSS.n538 VSS.n494 0.001
R10043 VSS.n519 VSS.n487 0.001
R10044 VSS.n522 VSS.n518 0.001
R10045 VSS.n523 VSS.n517 0.001
R10046 VSS.n526 VSS.n525 0.001
R10047 VSS.n179 VSS.n178 0.001
R10048 VSS.n1402 VSS.n1394 0.001
R10049 VSS.n1403 VSS.n1395 0.001
R10050 VSS.n1404 VSS.n1396 0.001
R10051 VSS.n1405 VSS.n1397 0.001
R10052 VSS.n1406 VSS.n1398 0.001
R10053 VSS.n1407 VSS.n1399 0.001
R10054 VSS.n1414 VSS.n1400 0.001
R10055 VSS.n1415 VSS.n1401 0.001
R10056 VSS.n1409 VSS.n1408 0.001
R10057 VSS.n1412 VSS.n1410 0.001
R10058 VSS.n309 VSS.n266 0.001
R10059 VSS.n311 VSS.n267 0.001
R10060 VSS.n313 VSS.n268 0.001
R10061 VSS.n315 VSS.n269 0.001
R10062 VSS.n769 VSS.n270 0.001
R10063 VSS.n366 VSS.n322 0.001
R10064 VSS.n342 VSS.n331 0.001
R10065 VSS.n344 VSS.n332 0.001
R10066 VSS.n346 VSS.n333 0.001
R10067 VSS.n348 VSS.n334 0.001
R10068 VSS.n350 VSS.n335 0.001
R10069 VSS.n352 VSS.n336 0.001
R10070 VSS.n354 VSS.n337 0.001
R10071 VSS.n356 VSS.n338 0.001
R10072 VSS.n358 VSS.n339 0.001
R10073 VSS.n360 VSS.n340 0.001
R10074 VSS.n363 VSS.n341 0.001
R10075 VSS.n365 VSS.n364 0.001
R10076 VSS.n1994 VSS.n1993 0.001
R10077 VSS.n1996 VSS.n1989 0.001
R10078 VSS.n774 VSS.n259 0.001
R10079 VSS.n851 VSS.n260 0.001
R10080 VSS.n871 VSS.n261 0.001
R10081 VSS.n891 VSS.n262 0.001
R10082 VSS.n1023 VSS.n257 0.001
R10083 VSS.n178 VSS.n177 0.001
R10084 VSS.n1994 VSS.n1989 0.001
R10085 VSS.n1997 VSS.n1996 0.001
R10086 VSS.n1024 VSS.n1023 0.001
R10087 VSS.n262 VSS.n257 0.001
R10088 VSS.n891 VSS.n261 0.001
R10089 VSS.n871 VSS.n260 0.001
R10090 VSS.n851 VSS.n259 0.001
R10091 VSS.n1408 VSS.n1401 0.001
R10092 VSS.n1410 VSS.n1409 0.001
R10093 VSS.n1412 VSS.n1411 0.001
R10094 VSS.n1403 VSS.n1396 0.001
R10095 VSS.n1404 VSS.n1397 0.001
R10096 VSS.n1405 VSS.n1398 0.001
R10097 VSS.n1406 VSS.n1399 0.001
R10098 VSS.n1407 VSS.n1400 0.001
R10099 VSS.n1415 VSS.n1414 0.001
R10100 VSS.n1402 VSS.n1395 0.001
R10101 VSS.n1059 VSS.n1058 0.00099359
R10102 VSS.n1063 VSS.n1062 0.00099359
R10103 VSS.n1051 VSS.n1047 0.00099359
R10104 VSS.n1048 VSS.n224 0.00099359
R10105 VSS.n1073 VSS.n1072 0.00099359
R10106 VSS.n1079 VSS.n1078 0.00099359
R10107 VSS.n1074 VSS.n216 0.00099359
R10108 VSS.n1091 VSS.n1089 0.00099359
R10109 VSS.n1094 VSS.n214 0.00099359
R10110 VSS.n1100 VSS.n1099 0.00099359
R10111 VSS.n1671 VSS.n1330 0.00099359
R10112 VSS.n1682 VSS.n1317 0.00099359
R10113 VSS.n1324 VSS.n1318 0.00099359
R10114 VSS.n1321 VSS.n1311 0.00099359
R10115 VSS.n1696 VSS.n1691 0.00099359
R10116 VSS.n1693 VSS.n1305 0.00099359
R10117 VSS.n1709 VSS.n1708 0.00099359
R10118 VSS.n1713 VSS.n1712 0.00099359
R10119 VSS.n1715 VSS.n1300 0.00099359
R10120 VSS.n1718 VSS.n1303 0.00099359
R10121 VSS.n1330 VSS.n1329 0.000887821
R10122 VSS.n1682 VSS.n1681 0.000887821
R10123 VSS.n1320 VSS.n1318 0.000887821
R10124 VSS.n1697 VSS.n1311 0.000887821
R10125 VSS.n1692 VSS.n1691 0.000887821
R10126 VSS.n1707 VSS.n1305 0.000887821
R10127 VSS.n1708 VSS.n1304 0.000887821
R10128 VSS.n1714 VSS.n1713 0.000887821
R10129 VSS.n1719 VSS.n1300 0.000887821
R10130 VSS.n1303 VSS.n1302 0.000887821
R10131 VSS.n1524 VSS.n1523 0.000861248
R10132 VSS.n843 VSS.n834 0.000852564
R10133 VSS.n858 VSS.n855 0.000852564
R10134 VSS.n856 VSS.n827 0.000852564
R10135 VSS.n867 VSS.n866 0.000852564
R10136 VSS.n829 VSS.n824 0.000852564
R10137 VSS.n878 VSS.n875 0.000852564
R10138 VSS.n876 VSS.n817 0.000852564
R10139 VSS.n887 VSS.n886 0.000852564
R10140 VSS.n1058 VSS.n1057 0.000852564
R10141 VSS.n1063 VSS.n229 0.000852564
R10142 VSS.n1047 VSS.n230 0.000852564
R10143 VSS.n1052 VSS.n224 0.000852564
R10144 VSS.n1072 VSS.n222 0.000852564
R10145 VSS.n1080 VSS.n1079 0.000852564
R10146 VSS.n1075 VSS.n1074 0.000852564
R10147 VSS.n1089 VSS.n1088 0.000852564
R10148 VSS.n1090 VSS.n214 0.000852564
R10149 VSS.n1101 VSS.n1100 0.000852564
R10150 VSS.n1774 VSS.n1271 0.000817308
R10151 VSS.n1785 VSS.n1784 0.000817308
R10152 VSS.n1780 VSS.n1779 0.000817308
R10153 VSS.n1794 VSS.n1793 0.000817308
R10154 VSS.n1795 VSS.n1263 0.000817308
R10155 VSS.n1806 VSS.n1805 0.000817308
R10156 VSS.n1801 VSS.n1800 0.000817308
R10157 VSS.n1813 VSS.n1812 0.000817308
R10158 VSS.n1554 VSS.n1553 0.000716749
R10159 VSS.n1634 VSS.n1632 0.000711538
R10160 VSS.n1095 VSS.n207 0.000641026
R10161 VSS.n1112 VSS.n1111 0.000641026
R10162 VSS.n1108 VSS.n189 0.000641026
R10163 VSS.n1983 VSS.n1982 0.000641026
R10164 VSS.n1635 VSS.n1428 0.000641026
R10165 VSS.n1639 VSS.n1638 0.000641026
R10166 VSS.n1642 VSS.n1641 0.000641026
R10167 VSS.n1643 VSS.n1339 0.000641026
R10168 VSS.n1648 VSS.n1646 0.000641026
R10169 VSS.n1649 VSS.n1338 0.000641026
R10170 VSS.n1657 VSS.n1652 0.000641026
R10171 VSS.n1656 VSS.n1653 0.000641026
R10172 VSS.n1666 VSS.n1331 0.000641026
R10173 VSS.n1668 VSS.n1328 0.000641026
R10174 VSS.n1602 VSS.n1600 0.00057225
R10175 VSS.n1728 VSS.n1293 0.000535256
R10176 VSS.n1729 VSS.n1291 0.000535256
R10177 VSS.n1742 VSS.n1735 0.000535256
R10178 VSS.n1737 VSS.n1736 0.000535256
R10179 VSS.n1752 VSS.n1284 0.000535256
R10180 VSS.n1753 VSS.n1283 0.000535256
R10181 VSS.n1760 VSS.n1759 0.000535256
R10182 VSS.n1765 VSS.n1279 0.000535256
R10183 VSS.n1282 VSS.n1281 0.000535256
R10184 VSS.n1773 VSS.n1273 0.000535256
C0 a_n8929_2739# VNin 0.0289f
C1 a_n3341_6527# a_n9221_n275# 0.02257f
C2 a_n10179_n275# a_1220_1772# 0.22923f
C3 a_n8929_2739# CMFBout 0.01733f
C4 a_1220_1772# Vop 13.8575f
C5 a_n10013_2465# a_n10179_n275# 0.28003f
C6 a_n2002_n4396# CMFBout 3.35199f
C7 a_n2002_n4396# a_36_n4396# 3.13992f
C8 a_3041_6527# VDD 5.294f
C9 a_n10013_2465# Vop 0.09216f
C10 a_n2373_n10895# VDD 0.01827f
C11 a_881_4136# CMFBin 0
C12 a_881_4136# a_286_1773# 0.16329f
C13 a_n20570_n9414# VOUTN 16.4295f
C14 a_n3381_1772# Von 0.10842f
C15 a_n2373_n10895# IB 0.19006f
C16 a_n14155_n5285# Von 3.65707f
C17 a_n3381_1772# CMFBin 0
C18 a_n10179_n275# a_n1828_1772# 0
C19 VDD VNout 0.1647f
C20 VDD VP 0.00283f
C21 VPin VNin 0.09755f
C22 VNout VPout 0.36163f
C23 a_11820_n9920# VOUTP 0.10813f
C24 a_n11981_1071# VDD 0.00819f
C25 a_n14155_n5285# a_n14528_n9920# 7.37693f
C26 a_11820_n9920# a_13228_n9920# 0.84529f
C27 VPout VP 0.02063f
C28 Vop VOUTP 0.25834f
C29 a_13228_n9920# Vop 0.00384f
C30 a_286_1773# CMFBin 0
C31 VREF CMFBout 0.02729f
C32 a_36_n4396# VREF 2.38885f
C33 a_n3162_51# VNin 1.27373f
C34 a_n14528_n9920# Von 3.26927f
C35 a_n3162_51# CMFBout 0.37174f
C36 a_n3341_6417# VDD 0.00489f
C37 a_n13845_n10915# a_n2373_n10895# 0.02689f
C38 a_1220_1772# a_881_4136# 11.7123f
C39 a_11862_1071# VP 0.02408f
C40 a_n6543_n10895# VDD 61.7909f
C41 a_n9221_n275# VNin 0.13082f
C42 a_n10179_n275# a_n8929_2739# 2.85499f
C43 a_n10013_2465# a_881_4136# 4.41545f
C44 a_n3341_6527# a_n3341_6417# 0.03505f
C45 a_n9221_n275# CMFBout 0.01709f
C46 a_n10106_3341# a_n10179_n275# 0.20815f
C47 a_n10013_2465# a_n3381_1772# 4.43267f
C48 a_n5006_n3441# CMFBout 3.20053f
C49 a_n20570_n9414# a_n14155_n5285# 0.84529f
C50 a_n5006_n3441# a_36_n4396# 2.99049f
C51 a_4667_n7511# VDD 0.03341f
C52 a_1220_1772# CMFBin 0.00236f
C53 a_n2002_n4396# Vop 1.07673f
C54 a_1220_1772# a_286_1773# 8.04639f
C55 a_n10013_2465# Von 0.57989f
C56 a_4667_n7511# IB 0.0179f
C57 a_n20570_n9414# Von 0.00384f
C58 a_n10013_2465# CMFBin 0
C59 a_n3381_1772# a_n1828_1772# 0.16329f
C60 a_n10013_2465# a_286_1773# 0.16331f
C61 a_3041_6417# Vop 0
C62 a_11820_n9920# a_11652_n9920# 7.37693f
C63 a_11652_n9920# Vop 3.26927f
C64 a_n10179_n275# VPin 0.00114f
C65 a_n20570_n9414# a_n14528_n9920# 7.38379f
C66 a_n6543_n10895# a_n13845_n10915# 0.03604f
C67 a_n1828_1772# CMFBin 0
C68 Von VN 0.00718f
C69 VDD VPout 0.19705f
C70 VNout VNin 0.18099f
C71 a_n11981_2661# VNout 0.02405f
C72 Vop VREF 0.16891f
C73 VDD IB 0.48698f
C74 a_n10179_n275# a_n3162_51# 0.43576f
C75 a_n3341_6527# VDD 5.294f
C76 a_n6543_n9623# a_n2373_n10895# 9.36663f
C77 a_n8929_2739# a_881_4136# 0.00895f
C78 a_11862_1071# VDD 0.0082f
C79 a_n3381_1772# a_n8929_2739# 0.01472f
C80 a_n10179_n275# a_n9221_n275# 0.40721f
C81 a_n10013_2465# a_1220_1772# 0.02842f
C82 a_11862_1071# VPout 0.02375f
C83 a_n9221_n275# Vop 0.00666f
C84 a_n10106_3341# a_n3381_1772# 11.7123f
C85 a_n6543_n10895# CMFBout 0.89595f
C86 a_n6543_n10895# a_36_n4396# 0.00479f
C87 a_n8929_2739# Von 0.20908f
C88 a_n13845_n10915# VDD 0.53905f
C89 a_n8929_2739# CMFBin 0.01204f
C90 a_n5006_n3441# Vop 0.1352f
C91 a_n8929_2739# a_286_1773# 0.64566f
C92 a_881_4136# a_3041_6417# 0.00168f
C93 a_n10106_3341# Von 13.8575f
C94 a_n13845_n10915# IB 0.02707f
C95 a_n2002_n4396# Von 0.00231f
C96 a_n10106_3341# CMFBin 0.00624f
C97 a_n10179_n275# a_3041_6527# 0.08304f
C98 a_n10013_2465# a_n1828_1772# 0.2949f
C99 a_n10179_n275# a_n2373_n10895# 0
C100 a_3041_6527# Vop 2.36197f
C101 a_n3381_1772# VPin 0
C102 a_n6543_n10895# a_n6543_n9623# 2.06122f
C103 a_881_4136# a_n3162_51# 0.04958f
C104 a_n10179_n275# VNout 0.0964f
C105 a_n3381_1772# a_n3162_51# 0.04909f
C106 VDD VNin 0.02656f
C107 a_n11981_2661# VDD 0.07804f
C108 VPin CMFBin 0.00526f
C109 VDD CMFBout 1.47928f
C110 VNin VPout 0.17095f
C111 Vop VP 0.00717f
C112 a_n6543_n9623# a_4667_n7511# 0.0299f
C113 a_n3721_n10895# a_n2373_n10895# 1.01965f
C114 a_36_n4396# VDD 0.29303f
C115 a_286_1773# VPin 0.00709f
C116 a_n8929_2739# a_1220_1772# 0.72695f
C117 a_n9221_n275# a_881_4136# 2.58487f
C118 a_13228_n9920# VOUTP 16.4295f
C119 a_11862_2661# VDD 0.07783f
C120 a_n3381_1772# a_n9221_n275# 2.6022f
C121 a_n10013_2465# a_n8929_2739# 0.37495f
C122 a_11862_2661# VPout 0.02406f
C123 a_n3162_51# CMFBin 10.6652f
C124 a_286_1773# a_n3162_51# 6.56765f
C125 a_n10106_3341# a_n10013_2465# 0.98268f
C126 a_n10179_n275# a_n6543_n10895# 0.0347f
C127 a_n9221_n275# Von 0.48122f
C128 a_n6543_n9623# VDD 0.82077f
C129 a_n9221_n275# CMFBin 0.01556f
C130 a_n6543_n10895# Vop 0.18692f
C131 a_1220_1772# a_3041_6417# 0.03065f
C132 a_881_4136# a_3041_6527# 0.1967f
C133 a_n8929_2739# a_n1828_1772# 0.64575f
C134 a_n9221_n275# a_286_1773# 0.06992f
C135 a_n6543_n9623# IB 0.81687f
C136 a_n5006_n3441# Von 0.99661f
C137 a_n10106_3341# a_n1828_1772# 8.04639f
C138 a_n6543_n10895# a_n3721_n10895# 0.52009f
C139 a_n10013_2465# VPin 0.24366f
C140 a_1220_1772# a_n3162_51# 0.04917f
C141 a_n3381_1772# VNout 0.01354f
C142 a_n10013_2465# a_n3162_51# 0.19179f
C143 a_n10179_n275# VDD 1.43329f
C144 a_11652_n9920# VOUTP 3.91871f
C145 a_n6543_n9623# a_n13845_n10915# 1.86748f
C146 a_n1828_1772# VPin 1.19853f
C147 a_n3721_n10895# a_4667_n7511# 0.0013f
C148 a_13228_n9920# a_11652_n9920# 7.38379f
C149 a_11820_n9920# VDD 14.7005f
C150 a_n10179_n275# VPout 0.10009f
C151 a_n9221_n275# a_1220_1772# 3.04282f
C152 VDD Vop 49.575f
C153 Von VNout 0.46584f
C154 VNout CMFBin 0.0014f
C155 VDD VOUTN 52.4143f
C156 Vop VPout 0.49492f
C157 a_11820_n9920# IB 0.00291f
C158 a_n11981_1071# Von 0.00819f
C159 a_286_1773# VNout 0.01207f
C160 a_n3381_1772# a_n3341_6417# 0.00168f
C161 a_n10106_3341# a_n8929_2739# 0.74866f
C162 a_n10013_2465# a_n9221_n275# 1.94535f
C163 a_n10179_n275# a_n3341_6527# 0.08304f
C164 Vop IB 0.15803f
C165 VNin CMFBout 0.01435f
C166 a_n1828_1772# a_n3162_51# 6.56765f
C167 a_36_n4396# CMFBout 0.33119f
C168 a_n3341_6417# Von 0
C169 a_n3721_n10895# VDD 24.9297f
C170 a_11862_1071# Vop 0.00818f
C171 a_1220_1772# a_3041_6527# 0.15611f
C172 a_n9221_n275# a_n1828_1772# 0.03031f
C173 a_n3721_n10895# IB 0.43069f
C174 a_n6543_n10895# Von 0.16428f
C175 a_n10013_2465# a_3041_6527# 0.09837f
C176 a_n6543_n10895# CMFBin 0.00849f
C177 a_n10179_n275# a_n13845_n10915# 0.47346f
C178 a_n8929_2739# VPin 0.02835f
C179 a_n13845_n10915# VOUTN 0.33015f
C180 a_n10106_3341# VPin 0.06973f
C181 a_n8929_2739# a_n3162_51# 0.12403f
C182 a_n2002_n4396# VREF 1.15424f
C183 a_881_4136# VDD 12.6171f
C184 a_n10013_2465# VNout 0.34311f
C185 a_881_4136# VPout 0.01374f
C186 a_n10106_3341# a_n3162_51# 0.05256f
C187 a_n3381_1772# VDD 12.6171f
C188 a_n14155_n5285# VDD 14.7005f
C189 a_n3721_n10895# a_n13845_n10915# 0.53117f
C190 a_n9221_n275# a_n8929_2739# 5.40147f
C191 a_n10179_n275# VNin 0.00116f
C192 a_n1828_1772# VNout 0.12334f
C193 a_n10106_3341# a_n9221_n275# 3.0999f
C194 a_n3381_1772# a_n3341_6527# 0.1967f
C195 VDD Von 49.5557f
C196 a_n10179_n275# CMFBout 0.06311f
C197 a_n10179_n275# a_36_n4396# 0
C198 VNout VN 0.02054f
C199 VDD CMFBin 0.0042f
C200 a_286_1773# VDD 0.11745f
C201 Vop CMFBout 1.67114f
C202 a_36_n4396# Vop 0.27487f
C203 a_n11981_1071# VN 0.02408f
C204 a_286_1773# VPout 0.12507f
C205 a_n3341_6527# Von 2.36197f
C206 a_n5006_n3441# a_n2002_n4396# 4.319f
C207 a_n3162_51# VPin 1.27376f
C208 a_n14528_n9920# VDD 0.12266f
C209 a_11862_2661# Vop 0.0505f
C210 a_n10179_n275# a_n6543_n9623# 0.19256f
C211 a_n3721_n10895# CMFBout 0.00877f
C212 a_36_n4396# a_n3721_n10895# 0.00848f
C213 a_n14155_n5285# a_n13845_n10915# 0.00867f
C214 a_n9221_n275# VPin 0.10641f
C215 a_n8929_2739# VNout 0.04683f
C216 a_n13845_n10915# Von 0.17986f
C217 a_n9221_n275# a_n3162_51# 0.16106f
C218 a_3041_6527# a_3041_6417# 0.03505f
C219 a_n5006_n3441# VREF 0.91764f
C220 a_n10106_3341# VNout 0.80377f
C221 a_1220_1772# VDD 26.2452f
C222 a_1220_1772# VPout 0.81919f
C223 a_n10013_2465# VDD 41.0906f
C224 a_n14528_n9920# a_n13845_n10915# 0.49761f
C225 a_n20570_n9414# VDD 12.0898f
C226 a_881_4136# VNin 0
C227 a_n3721_n10895# a_n6543_n9623# 6.54978f
C228 a_n10013_2465# VPout 0.07635f
C229 a_881_4136# CMFBout 0.00166f
C230 a_n10013_2465# a_n3341_6527# 0.09837f
C231 a_n10106_3341# a_n3341_6417# 0.03065f
C232 a_n1828_1772# VDD 0.11745f
C233 a_n10179_n275# Vop 9.96094f
C234 a_11820_n9920# Vop 3.65896f
C235 a_n1828_1772# VPout 0.01086f
C236 VDD VN 0.00282f
C237 VNout VPin 0.17415f
C238 a_n6543_n10895# a_n2002_n4396# 4.64733f
C239 a_n11981_2661# Von 0.05204f
C240 Von CMFBout 1.28329f
C241 VDD VOUTP 52.4366f
C242 VNin CMFBin 0.00512f
C243 a_286_1773# VNin 1.19946f
C244 a_13228_n9920# VDD 12.0898f
C245 a_n9221_n275# a_3041_6527# 0.02257f
C246 CMFBin CMFBout 0.34588f
C247 a_286_1773# CMFBout 0.00466f
C248 VOUTP IB 0.33015f
C249 a_n3162_51# VNout 0.10945f
C250 a_n10179_n275# a_n3721_n10895# 0.8627f
C251 a_n9221_n275# VNout 0.05068f
C252 a_n6543_n10895# VREF 0.2342f
C253 a_n8929_2739# VDD 0.22092f
C254 a_n8929_2739# VPout 0.02808f
C255 a_n10106_3341# VDD 26.5195f
C256 a_n3162_51# a_n6543_n10895# 0
C257 a_n2002_n4396# VDD 8.79638f
C258 a_1220_1772# VNin 0.06805f
C259 a_n10179_n275# a_881_4136# 0.0077f
C260 a_1220_1772# CMFBout 0.04883f
C261 a_881_4136# Vop 0.10842f
C262 a_n10013_2465# VNin 0.06264f
C263 a_n10106_3341# a_n3341_6527# 0.15611f
C264 a_n3381_1772# a_n10179_n275# 0.00364f
C265 a_3041_6417# VDD 0.00489f
C266 a_11652_n9920# VDD 0.12266f
C267 a_n14155_n5285# VOUTN 0.11824f
C268 a_n6543_n10895# a_n5006_n3441# 4.88969f
C269 a_n10179_n275# Von 10.1134f
C270 a_11652_n9920# IB 0.48531f
C271 a_n1828_1772# VNin 0.00709f
C272 a_n10179_n275# CMFBin 0.11179f
C273 a_n10179_n275# a_286_1773# 0
C274 Von Vop 0.03842f
C275 VDD VPin 0.02668f
C276 Von VOUTN 0.25834f
C277 VDD VREF 5.59269f
C278 VPin VPout 0.17968f
C279 a_n11981_1071# VNout 0.02376f
C280 a_n3162_51# VDD 0.02036f
C281 a_n6543_n10895# a_n2373_n10895# 0.00252f
C282 a_n3162_51# VPout 0.07823f
C283 a_n14528_n9920# VOUTN 3.91871f
C284 a_n9221_n275# VDD 13.4249f
C285 a_4667_n7511# a_n2373_n10895# 0.07082f
C286 a_n9221_n275# VPout 0.02438f
C287 a_n5006_n3441# VDD 8.9765f
C288 IB VSS 8.68514f
C289 VOUTP VSS 38.79992f
C290 CMFBout VSS 17.10263f
C291 VREF VSS 1.61417f
C292 VOUTN VSS 38.79122f
C293 VP VSS 0.46127f
C294 CMFBin VSS 11.59466f
C295 VPout VSS 5.20105f
C296 VN VSS 0.49382f
C297 VNin VSS 1.94089f
C298 VPin VSS 2.8817f
C299 Vop VSS 48.50228f
C300 VNout VSS 5.33578f
C301 Von VSS 45.7706f
C302 VDD VSS 0.18852p
C303 a_11652_n9920# VSS 7.35278f
C304 a_n2373_n10895# VSS 9.264f
C305 a_4667_n7511# VSS 2.04489f $ **FLOATING
C306 a_n13845_n10915# VSS 8.21447f
C307 a_n6543_n9623# VSS 93.3707f
C308 a_n3721_n10895# VSS 14.9663f
C309 a_n14528_n9920# VSS 7.35278f
C310 a_13228_n9920# VSS 21.6544f
C311 a_36_n4396# VSS 6.73452f
C312 a_11820_n9920# VSS 3.26817f
C313 a_n14155_n5285# VSS 3.2664f
C314 a_n20570_n9414# VSS 21.6544f
C315 a_n2002_n4396# VSS 1.73152f
C316 a_n5006_n3441# VSS 1.69641f
C317 a_n6543_n10895# VSS 10.6804f
C318 a_11862_1071# VSS 0.95252f $ **FLOATING
C319 a_11862_2661# VSS 2.67682f $ **FLOATING
C320 a_n3162_51# VSS 21.896f
C321 a_n11981_1071# VSS 0.95252f $ **FLOATING
C322 a_286_1773# VSS 1.32762f
C323 a_n1828_1772# VSS 1.32671f
C324 a_3041_6417# VSS 0.12038f $ **FLOATING
C325 a_3041_6527# VSS 2.31209f
C326 a_881_4136# VSS 3.60392f
C327 a_1220_1772# VSS 7.46437f
C328 a_n8929_2739# VSS 6.24766f
C329 a_n9221_n275# VSS 3.31228f
C330 a_n3341_6417# VSS 0.12038f $ **FLOATING
C331 a_n3341_6527# VSS 2.31209f
C332 a_n11981_2661# VSS 2.67677f $ **FLOATING
C333 a_n10179_n275# VSS 92.3581f
C334 a_n3381_1772# VSS 3.60459f
C335 a_n10013_2465# VSS 5.10503f
C336 a_n10106_3341# VSS 7.49327f
C337 VDD.n0 VSS 27.4941f
C338 VDD.n1 VSS 1.26621f
C339 VDD.n2 VSS 0.01917f
C340 VDD.n3 VSS 0.02556f
C341 VDD.n4 VSS 0.02556f
C342 VDD.n5 VSS 0.02556f
C343 VDD.n6 VSS 0.02556f
C344 VDD.n7 VSS 0.02556f
C345 VDD.n8 VSS 0.02556f
C346 VDD.n9 VSS 0.02556f
C347 VDD.n10 VSS 0.07151f
C348 VDD.n11 VSS 0.00514f
C349 VDD.n12 VSS 0.00514f
C350 VDD.n13 VSS 0.00514f
C351 VDD.n14 VSS 0.43174f
C352 VDD.n15 VSS 0.07217f
C353 VDD.n16 VSS 0.02735f
C354 VDD.n17 VSS 0.03015f
C355 VDD.n19 VSS 0.02735f
C356 VDD.n20 VSS 0.01513f
C357 VDD.n21 VSS 0.03818f
C358 VDD.n22 VSS 0.10551f
C359 VDD.n23 VSS 0.02474f
C360 VDD.n24 VSS 1.35237f
C361 VDD.n25 VSS 0.10551f
C362 VDD.n26 VSS 0.07111f
C363 VDD.n27 VSS 0.09419f
C364 VDD.n28 VSS 0.06588f
C365 VDD.n29 VSS 0.07186f
C366 VDD.n30 VSS 0.02556f
C367 VDD.n31 VSS 0.02556f
C368 VDD.n32 VSS 0.02556f
C369 VDD.n33 VSS 0.02556f
C370 VDD.n34 VSS 0.02556f
C371 VDD.n35 VSS 0.01917f
C372 VDD.n36 VSS 1.26621f
C373 VDD.n37 VSS 0.01917f
C374 VDD.n38 VSS 0.02556f
C375 VDD.n39 VSS 0.02556f
C376 VDD.n40 VSS 0.02556f
C377 VDD.n41 VSS 0.02556f
C378 VDD.n42 VSS 0.02556f
C379 VDD.n43 VSS 0.02556f
C380 VDD.n44 VSS 0.0269f
C381 VDD.n45 VSS 0.0269f
C382 VDD.n46 VSS 0.0269f
C383 VDD.n47 VSS 0.02556f
C384 VDD.n48 VSS 0.07151f
C385 VDD.n49 VSS 0.02556f
C386 VDD.n50 VSS 0.02556f
C387 VDD.n51 VSS 0.0269f
C388 VDD.n52 VSS 0.0269f
C389 VDD.n53 VSS 0.0269f
C390 VDD.n54 VSS 0.07151f
C391 VDD.n55 VSS 0.02556f
C392 VDD.n56 VSS 0.02556f
C393 VDD.n57 VSS 0.02556f
C394 VDD.n58 VSS 0.02556f
C395 VDD.n59 VSS 0.02556f
C396 VDD.n60 VSS 0.07151f
C397 VDD.n61 VSS 0.02556f
C398 VDD.n62 VSS 0.02556f
C399 VDD.n63 VSS 0.02556f
C400 VDD.n64 VSS 0.02556f
C401 VDD.n65 VSS 0.02556f
C402 VDD.n66 VSS 0.07523f
C403 VDD.n67 VSS 0.0269f
C404 VDD.n68 VSS 0.0269f
C405 VDD.n69 VSS 0.02556f
C406 VDD.n70 VSS 0.02556f
C407 VDD.n71 VSS 0.02556f
C408 VDD.n72 VSS 0.07151f
C409 VDD.n73 VSS 0.02556f
C410 VDD.n74 VSS 0.02556f
C411 VDD.n75 VSS 0.01278f
C412 VDD.n76 VSS 0.02556f
C413 VDD.n77 VSS 0.02556f
C414 VDD.n78 VSS 0.07151f
C415 VDD.n79 VSS 0.02556f
C416 VDD.n80 VSS 0.02556f
C417 VDD.n81 VSS 0.0269f
C418 VDD.n82 VSS 0.0269f
C419 VDD.n83 VSS 0.0269f
C420 VDD.n84 VSS 0.07151f
C421 VDD.n85 VSS 0.02556f
C422 VDD.n86 VSS 0.02556f
C423 VDD.n87 VSS 0.02556f
C424 VDD.n88 VSS 0.02556f
C425 VDD.n89 VSS 0.02556f
C426 VDD.n90 VSS 0.07151f
C427 VDD.n91 VSS 0.02556f
C428 VDD.n92 VSS 0.02556f
C429 VDD.n93 VSS 0.01917f
C430 VDD.n94 VSS 1.26621f
C431 VDD.n95 VSS 0.01917f
C432 VDD.n96 VSS 0.02556f
C433 VDD.n97 VSS 0.02556f
C434 VDD.n98 VSS 0.02556f
C435 VDD.n99 VSS 0.02556f
C436 VDD.n100 VSS 0.02556f
C437 VDD.n101 VSS 0.02556f
C438 VDD.n102 VSS 0.0269f
C439 VDD.n103 VSS 0.0269f
C440 VDD.n104 VSS 0.0269f
C441 VDD.n105 VSS 0.02556f
C442 VDD.n106 VSS 0.02556f
C443 VDD.n107 VSS 0.02556f
C444 VDD.n108 VSS 0.07186f
C445 VDD.n109 VSS 0.02556f
C446 VDD.n110 VSS 0.02556f
C447 VDD.n111 VSS 0.0269f
C448 VDD.n112 VSS 0.0269f
C449 VDD.n113 VSS 0.0269f
C450 VDD.n114 VSS 0.07186f
C451 VDD.n115 VSS 0.02556f
C452 VDD.n116 VSS 0.02556f
C453 VDD.n117 VSS 0.02556f
C454 VDD.n118 VSS 0.02556f
C455 VDD.n119 VSS 0.02556f
C456 VDD.n120 VSS 0.07186f
C457 VDD.n121 VSS 0.02556f
C458 VDD.n122 VSS 0.02556f
C459 VDD.n123 VSS 0.02556f
C460 VDD.n124 VSS 0.02556f
C461 VDD.n125 VSS 0.02556f
C462 VDD.n126 VSS 0.07561f
C463 VDD.n127 VSS 0.0269f
C464 VDD.n128 VSS 0.0269f
C465 VDD.n129 VSS 0.02556f
C466 VDD.n130 VSS 0.02556f
C467 VDD.n131 VSS 0.02556f
C468 VDD.n132 VSS 0.07151f
C469 VDD.n133 VSS 0.02556f
C470 VDD.n134 VSS 0.02556f
C471 VDD.n135 VSS 0.29623f
C472 VDD.n136 VSS 0.1003f
C473 VDD.n137 VSS 0.11018f
C474 VDD.n138 VSS 0.11018f
C475 VDD.n139 VSS 0.11199f
C476 VDD.n140 VSS 0.29623f
C477 VDD.n141 VSS 0.11018f
C478 VDD.n142 VSS 0.11018f
C479 VDD.n143 VSS 0.11018f
C480 VDD.n144 VSS 0.11199f
C481 VDD.n145 VSS 0.29623f
C482 VDD.n146 VSS 0.11018f
C483 VDD.n147 VSS 0.11018f
C484 VDD.n148 VSS 0.11018f
C485 VDD.t669 VSS 0.01457f
C486 VDD.t950 VSS 0.01516f
C487 VDD.t902 VSS 0.01415f
C488 VDD.n149 VSS 0.01413f
C489 VDD.t855 VSS 0.01415f
C490 VDD.n150 VSS 0.0081f
C491 VDD.t811 VSS 0.01415f
C492 VDD.n151 VSS 0.0081f
C493 VDD.t763 VSS 0.01415f
C494 VDD.n152 VSS 0.0081f
C495 VDD.t715 VSS 0.01415f
C496 VDD.n153 VSS 0.00601f
C497 VDD.n154 VSS 0.0105f
C498 VDD.n155 VSS 0.0426f
C499 VDD.n156 VSS 0.09684f
C500 VDD.t683 VSS 0.01457f
C501 VDD.t964 VSS 0.01516f
C502 VDD.t916 VSS 0.01415f
C503 VDD.n157 VSS 0.01413f
C504 VDD.t869 VSS 0.01415f
C505 VDD.n158 VSS 0.0081f
C506 VDD.t825 VSS 0.01415f
C507 VDD.n159 VSS 0.0081f
C508 VDD.t778 VSS 0.01415f
C509 VDD.n160 VSS 0.0081f
C510 VDD.t731 VSS 0.01415f
C511 VDD.n161 VSS 0.00601f
C512 VDD.n162 VSS 0.0105f
C513 VDD.n163 VSS 0.04907f
C514 VDD.t681 VSS 0.01457f
C515 VDD.t962 VSS 0.01516f
C516 VDD.t914 VSS 0.01415f
C517 VDD.n164 VSS 0.01413f
C518 VDD.t867 VSS 0.01415f
C519 VDD.n165 VSS 0.0081f
C520 VDD.t823 VSS 0.01415f
C521 VDD.n166 VSS 0.0081f
C522 VDD.t775 VSS 0.01415f
C523 VDD.n167 VSS 0.0081f
C524 VDD.t727 VSS 0.01415f
C525 VDD.n168 VSS 0.00601f
C526 VDD.n169 VSS 0.0105f
C527 VDD.n170 VSS 0.11018f
C528 VDD.n171 VSS 0.11018f
C529 VDD.t695 VSS 0.01457f
C530 VDD.t976 VSS 0.01516f
C531 VDD.t929 VSS 0.01415f
C532 VDD.n172 VSS 0.01413f
C533 VDD.t881 VSS 0.01415f
C534 VDD.n173 VSS 0.0081f
C535 VDD.t657 VSS 0.01415f
C536 VDD.n174 VSS 0.0081f
C537 VDD.t790 VSS 0.01415f
C538 VDD.n175 VSS 0.0081f
C539 VDD.t743 VSS 0.01415f
C540 VDD.n176 VSS 0.00601f
C541 VDD.n177 VSS 0.0105f
C542 VDD.n178 VSS 0.03101f
C543 VDD.n179 VSS 0.1003f
C544 VDD.t705 VSS 0.01308f
C545 VDD.t986 VSS 0.01367f
C546 VDD.t939 VSS 0.01266f
C547 VDD.n180 VSS 0.01413f
C548 VDD.t891 VSS 0.01266f
C549 VDD.n181 VSS 0.0081f
C550 VDD.t846 VSS 0.01266f
C551 VDD.n182 VSS 0.0081f
C552 VDD.t800 VSS 0.01266f
C553 VDD.n183 VSS 0.0081f
C554 VDD.t753 VSS 0.01266f
C555 VDD.n184 VSS 0.00601f
C556 VDD.n185 VSS 0.01119f
C557 VDD.n186 VSS 0.05009f
C558 VDD.t703 VSS 0.01457f
C559 VDD.t984 VSS 0.01516f
C560 VDD.t937 VSS 0.01415f
C561 VDD.n187 VSS 0.01413f
C562 VDD.t889 VSS 0.01415f
C563 VDD.n188 VSS 0.0081f
C564 VDD.t844 VSS 0.01415f
C565 VDD.n189 VSS 0.0081f
C566 VDD.t798 VSS 0.01415f
C567 VDD.n190 VSS 0.0081f
C568 VDD.t751 VSS 0.01415f
C569 VDD.n191 VSS 0.00601f
C570 VDD.n192 VSS 0.0105f
C571 VDD.n193 VSS 0.0301f
C572 VDD.t701 VSS 0.01457f
C573 VDD.t982 VSS 0.01516f
C574 VDD.t935 VSS 0.01415f
C575 VDD.n194 VSS 0.01413f
C576 VDD.t887 VSS 0.01415f
C577 VDD.n195 VSS 0.0081f
C578 VDD.t842 VSS 0.01415f
C579 VDD.n196 VSS 0.0081f
C580 VDD.t796 VSS 0.01415f
C581 VDD.n197 VSS 0.0081f
C582 VDD.t749 VSS 0.01415f
C583 VDD.n198 VSS 0.00601f
C584 VDD.n199 VSS 0.0105f
C585 VDD.n200 VSS 0.04907f
C586 VDD.t699 VSS 0.01457f
C587 VDD.t980 VSS 0.01516f
C588 VDD.t933 VSS 0.01415f
C589 VDD.n201 VSS 0.01413f
C590 VDD.t885 VSS 0.01415f
C591 VDD.n202 VSS 0.0081f
C592 VDD.t840 VSS 0.01415f
C593 VDD.n203 VSS 0.0081f
C594 VDD.t794 VSS 0.01415f
C595 VDD.n204 VSS 0.0081f
C596 VDD.t747 VSS 0.01415f
C597 VDD.n205 VSS 0.00601f
C598 VDD.n206 VSS 0.0105f
C599 VDD.n207 VSS 0.02499f
C600 VDD.t697 VSS 0.01457f
C601 VDD.t978 VSS 0.01516f
C602 VDD.t931 VSS 0.01415f
C603 VDD.n208 VSS 0.01413f
C604 VDD.t883 VSS 0.01415f
C605 VDD.n209 VSS 0.0081f
C606 VDD.t838 VSS 0.01415f
C607 VDD.n210 VSS 0.0081f
C608 VDD.t792 VSS 0.01415f
C609 VDD.n211 VSS 0.0081f
C610 VDD.t745 VSS 0.01415f
C611 VDD.n212 VSS 0.00601f
C612 VDD.n213 VSS 0.0105f
C613 VDD.n214 VSS 0.04862f
C614 VDD.n215 VSS 0.02454f
C615 VDD.n216 VSS 0.11018f
C616 VDD.n217 VSS 0.11018f
C617 VDD.n218 VSS 0.02454f
C618 VDD.t693 VSS 0.01457f
C619 VDD.t974 VSS 0.01516f
C620 VDD.t927 VSS 0.01415f
C621 VDD.n219 VSS 0.01413f
C622 VDD.t879 VSS 0.01415f
C623 VDD.n220 VSS 0.0081f
C624 VDD.t835 VSS 0.01415f
C625 VDD.n221 VSS 0.0081f
C626 VDD.t788 VSS 0.01415f
C627 VDD.n222 VSS 0.0081f
C628 VDD.t741 VSS 0.01415f
C629 VDD.n223 VSS 0.00601f
C630 VDD.n224 VSS 0.0105f
C631 VDD.n225 VSS 0.0426f
C632 VDD.t691 VSS 0.01457f
C633 VDD.t972 VSS 0.01516f
C634 VDD.t925 VSS 0.01415f
C635 VDD.n226 VSS 0.01413f
C636 VDD.t877 VSS 0.01415f
C637 VDD.n227 VSS 0.0081f
C638 VDD.t833 VSS 0.01415f
C639 VDD.n228 VSS 0.0081f
C640 VDD.t786 VSS 0.01415f
C641 VDD.n229 VSS 0.0081f
C642 VDD.t739 VSS 0.01415f
C643 VDD.n230 VSS 0.00601f
C644 VDD.n231 VSS 0.0105f
C645 VDD.n232 VSS 0.03703f
C646 VDD.n233 VSS 0.02454f
C647 VDD.t689 VSS 0.01457f
C648 VDD.t970 VSS 0.01516f
C649 VDD.t922 VSS 0.01415f
C650 VDD.n234 VSS 0.01413f
C651 VDD.t875 VSS 0.01415f
C652 VDD.n235 VSS 0.0081f
C653 VDD.t831 VSS 0.01415f
C654 VDD.n236 VSS 0.0081f
C655 VDD.t784 VSS 0.01415f
C656 VDD.n237 VSS 0.0081f
C657 VDD.t737 VSS 0.01415f
C658 VDD.n238 VSS 0.00601f
C659 VDD.n239 VSS 0.0105f
C660 VDD.n240 VSS 0.03658f
C661 VDD.t687 VSS 0.01457f
C662 VDD.t968 VSS 0.01516f
C663 VDD.t920 VSS 0.01415f
C664 VDD.n241 VSS 0.01413f
C665 VDD.t873 VSS 0.01415f
C666 VDD.n242 VSS 0.0081f
C667 VDD.t829 VSS 0.01415f
C668 VDD.n243 VSS 0.0081f
C669 VDD.t782 VSS 0.01415f
C670 VDD.n244 VSS 0.0081f
C671 VDD.t735 VSS 0.01415f
C672 VDD.n245 VSS 0.00601f
C673 VDD.n246 VSS 0.0105f
C674 VDD.n247 VSS 0.04305f
C675 VDD.t685 VSS 0.01457f
C676 VDD.t966 VSS 0.01516f
C677 VDD.t918 VSS 0.01415f
C678 VDD.n248 VSS 0.01413f
C679 VDD.t871 VSS 0.01415f
C680 VDD.n249 VSS 0.0081f
C681 VDD.t827 VSS 0.01415f
C682 VDD.n250 VSS 0.0081f
C683 VDD.t780 VSS 0.01415f
C684 VDD.n251 VSS 0.0081f
C685 VDD.t733 VSS 0.01415f
C686 VDD.n252 VSS 0.00601f
C687 VDD.n253 VSS 0.0105f
C688 VDD.n254 VSS 0.03056f
C689 VDD.n255 VSS 0.02454f
C690 VDD.n256 VSS 0.11018f
C691 VDD.t0 VSS 31.592f
C692 VDD.n257 VSS 0.1318f
C693 VDD.n258 VSS 0.06844f
C694 VDD.n259 VSS 0.04907f
C695 VDD.t679 VSS 0.01457f
C696 VDD.t960 VSS 0.01516f
C697 VDD.t912 VSS 0.01415f
C698 VDD.n260 VSS 0.01413f
C699 VDD.t865 VSS 0.01415f
C700 VDD.n261 VSS 0.0081f
C701 VDD.t821 VSS 0.01415f
C702 VDD.n262 VSS 0.0081f
C703 VDD.t773 VSS 0.01415f
C704 VDD.n263 VSS 0.0081f
C705 VDD.t725 VSS 0.01415f
C706 VDD.n264 VSS 0.00601f
C707 VDD.n265 VSS 0.0105f
C708 VDD.n266 VSS 0.04907f
C709 VDD.t677 VSS 0.01457f
C710 VDD.t958 VSS 0.01516f
C711 VDD.t910 VSS 0.01415f
C712 VDD.n267 VSS 0.01413f
C713 VDD.t863 VSS 0.01415f
C714 VDD.n268 VSS 0.0081f
C715 VDD.t819 VSS 0.01415f
C716 VDD.n269 VSS 0.0081f
C717 VDD.t771 VSS 0.01415f
C718 VDD.n270 VSS 0.0081f
C719 VDD.t723 VSS 0.01415f
C720 VDD.n271 VSS 0.00601f
C721 VDD.n272 VSS 0.0105f
C722 VDD.n273 VSS 0.03056f
C723 VDD.n274 VSS 0.02454f
C724 VDD.t675 VSS 0.01457f
C725 VDD.t956 VSS 0.01516f
C726 VDD.t908 VSS 0.01415f
C727 VDD.n275 VSS 0.01413f
C728 VDD.t861 VSS 0.01415f
C729 VDD.n276 VSS 0.0081f
C730 VDD.t817 VSS 0.01415f
C731 VDD.n277 VSS 0.0081f
C732 VDD.t769 VSS 0.01415f
C733 VDD.n278 VSS 0.0081f
C734 VDD.t721 VSS 0.01415f
C735 VDD.n279 VSS 0.00601f
C736 VDD.n280 VSS 0.0105f
C737 VDD.n281 VSS 0.04305f
C738 VDD.t673 VSS 0.01457f
C739 VDD.t954 VSS 0.01516f
C740 VDD.t906 VSS 0.01415f
C741 VDD.n282 VSS 0.01413f
C742 VDD.t859 VSS 0.01415f
C743 VDD.n283 VSS 0.0081f
C744 VDD.t815 VSS 0.01415f
C745 VDD.n284 VSS 0.0081f
C746 VDD.t767 VSS 0.01415f
C747 VDD.n285 VSS 0.0081f
C748 VDD.t719 VSS 0.01415f
C749 VDD.n286 VSS 0.00601f
C750 VDD.n287 VSS 0.0105f
C751 VDD.n288 VSS 0.03658f
C752 VDD.t671 VSS 0.01457f
C753 VDD.t952 VSS 0.01516f
C754 VDD.t904 VSS 0.01415f
C755 VDD.n289 VSS 0.01413f
C756 VDD.t857 VSS 0.01415f
C757 VDD.n290 VSS 0.0081f
C758 VDD.t813 VSS 0.01415f
C759 VDD.n291 VSS 0.0081f
C760 VDD.t765 VSS 0.01415f
C761 VDD.n292 VSS 0.0081f
C762 VDD.t717 VSS 0.01415f
C763 VDD.n293 VSS 0.00601f
C764 VDD.n294 VSS 0.0105f
C765 VDD.n295 VSS 0.03703f
C766 VDD.n296 VSS 0.02454f
C767 VDD.n297 VSS 0.11018f
C768 VDD.n298 VSS 0.11018f
C769 VDD.n299 VSS 0.11018f
C770 VDD.n300 VSS 0.02454f
C771 VDD.t667 VSS 0.01457f
C772 VDD.t948 VSS 0.01516f
C773 VDD.t900 VSS 0.01415f
C774 VDD.n301 VSS 0.01413f
C775 VDD.t853 VSS 0.01415f
C776 VDD.n302 VSS 0.0081f
C777 VDD.t809 VSS 0.01415f
C778 VDD.n303 VSS 0.0081f
C779 VDD.t761 VSS 0.01415f
C780 VDD.n304 VSS 0.0081f
C781 VDD.t713 VSS 0.01415f
C782 VDD.n305 VSS 0.00601f
C783 VDD.n306 VSS 0.0105f
C784 VDD.n307 VSS 0.03101f
C785 VDD.t665 VSS 0.01457f
C786 VDD.t946 VSS 0.01516f
C787 VDD.t898 VSS 0.01415f
C788 VDD.n308 VSS 0.01413f
C789 VDD.t851 VSS 0.01415f
C790 VDD.n309 VSS 0.0081f
C791 VDD.t807 VSS 0.01415f
C792 VDD.n310 VSS 0.0081f
C793 VDD.t759 VSS 0.01415f
C794 VDD.n311 VSS 0.0081f
C795 VDD.t711 VSS 0.01415f
C796 VDD.n312 VSS 0.00601f
C797 VDD.n313 VSS 0.0105f
C798 VDD.n314 VSS 0.04862f
C799 VDD.n315 VSS 0.02454f
C800 VDD.t663 VSS 0.01457f
C801 VDD.t944 VSS 0.01516f
C802 VDD.t896 VSS 0.01415f
C803 VDD.n316 VSS 0.01413f
C804 VDD.t655 VSS 0.01415f
C805 VDD.n317 VSS 0.0081f
C806 VDD.t776 VSS 0.01415f
C807 VDD.n318 VSS 0.0081f
C808 VDD.t757 VSS 0.01415f
C809 VDD.n319 VSS 0.0081f
C810 VDD.t709 VSS 0.01415f
C811 VDD.n320 VSS 0.00601f
C812 VDD.n321 VSS 0.0105f
C813 VDD.n322 VSS 0.02499f
C814 VDD.t661 VSS 0.01457f
C815 VDD.t942 VSS 0.01516f
C816 VDD.t894 VSS 0.01415f
C817 VDD.n323 VSS 0.01413f
C818 VDD.t848 VSS 0.01415f
C819 VDD.n324 VSS 0.0081f
C820 VDD.t804 VSS 0.01415f
C821 VDD.n325 VSS 0.0081f
C822 VDD.t729 VSS 0.01415f
C823 VDD.n326 VSS 0.0081f
C824 VDD.t707 VSS 0.01415f
C825 VDD.n327 VSS 0.00601f
C826 VDD.n328 VSS 0.0105f
C827 VDD.n329 VSS 0.04907f
C828 VDD.t659 VSS 0.01457f
C829 VDD.t940 VSS 0.01516f
C830 VDD.t892 VSS 0.01415f
C831 VDD.n330 VSS 0.01413f
C832 VDD.t654 VSS 0.01415f
C833 VDD.n331 VSS 0.0081f
C834 VDD.t802 VSS 0.01415f
C835 VDD.n332 VSS 0.0081f
C836 VDD.t754 VSS 0.01415f
C837 VDD.n333 VSS 0.0081f
C838 VDD.t652 VSS 0.01415f
C839 VDD.n334 VSS 0.00601f
C840 VDD.n335 VSS 0.0105f
C841 VDD.n336 VSS 0.0301f
C842 VDD.t658 VSS 0.01308f
C843 VDD.t923 VSS 0.01367f
C844 VDD.t656 VSS 0.01266f
C845 VDD.n337 VSS 0.01413f
C846 VDD.t653 VSS 0.01266f
C847 VDD.n338 VSS 0.0081f
C848 VDD.t801 VSS 0.01266f
C849 VDD.n339 VSS 0.0081f
C850 VDD.t728 VSS 0.01266f
C851 VDD.n340 VSS 0.0081f
C852 VDD.t651 VSS 0.01266f
C853 VDD.n341 VSS 0.00601f
C854 VDD.n342 VSS 0.01119f
C855 VDD.n343 VSS 0.05009f
C856 VDD.n344 VSS 0.1003f
C857 VDD.n345 VSS 0.1003f
C858 VDD.n346 VSS 0.17316f
C859 VDD.n347 VSS 0.10195f
C860 VDD.n348 VSS 0.11199f
C861 VDD.n349 VSS 0.11199f
C862 VDD.n350 VSS 0.29623f
C863 VDD.n351 VSS 0.29623f
C864 VDD.n352 VSS 0.29623f
C865 VDD.n353 VSS 0.11199f
C866 VDD.n354 VSS 0.11199f
C867 VDD.n355 VSS 0.11199f
C868 VDD.n356 VSS 0.29623f
C869 VDD.n357 VSS 0.29623f
C870 VDD.n358 VSS 0.29623f
C871 VDD.n359 VSS 0.11199f
C872 VDD.n360 VSS 0.11199f
C873 VDD.n361 VSS 0.10195f
C874 VDD.n362 VSS 1.44222f
C875 VDD.n363 VSS 0.00596f
C876 VDD.t634 VSS 0.1872f
C877 VDD.n364 VSS 0.03082f
C878 VDD.n365 VSS 0.01657f
C879 VDD.t637 VSS 0.1872f
C880 VDD.n366 VSS 0.04265f
C881 VDD.n367 VSS 0.01161f
C882 VDD.t636 VSS 0.17231f
C883 VDD.n368 VSS 0.06418f
C884 VDD.n369 VSS 0.16556f
C885 VDD.t635 VSS 0.1872f
C886 VDD.n370 VSS 0.03709f
C887 VDD.t641 VSS 0.17231f
C888 VDD.n371 VSS 0.06196f
C889 VDD.n372 VSS 0.01657f
C890 VDD.t633 VSS 6.47032f
C891 VDD.n373 VSS 0.6217f
C892 VDD.n374 VSS 0.00835f
C893 VDD.n375 VSS 0.08051f
C894 VDD.n376 VSS 1.5414f
C895 VDD.n377 VSS 0.04119f
C896 VDD.n378 VSS 0.0407f
C897 VDD.n379 VSS 0.05649f
C898 VDD.n380 VSS 0.05649f
C899 VDD.n381 VSS 0.06293f
C900 VDD.n384 VSS 0.15752f
C901 VDD.t613 VSS 0.31906f
C902 VDD.t615 VSS 0.18241f
C903 VDD.t614 VSS 0.18265f
C904 VDD.n385 VSS 0.55374f
C905 VDD.n386 VSS 0.22831f
C906 VDD.t617 VSS 0.18241f
C907 VDD.t616 VSS 0.18265f
C908 VDD.n387 VSS 0.55374f
C909 VDD.n388 VSS 0.22831f
C910 VDD.t619 VSS 0.18241f
C911 VDD.t618 VSS 0.18265f
C912 VDD.n389 VSS 0.55374f
C913 VDD.n390 VSS 0.22831f
C914 VDD.t612 VSS 0.12663f
C915 VDD.t604 VSS 0.12795f
C916 VDD.n391 VSS 0.11112f
C917 VDD.n392 VSS 0.0149f
C918 VDD.n393 VSS 0.03002f
C919 VDD.n394 VSS 0.03002f
C920 VDD.n395 VSS 0.02982f
C921 VDD.n396 VSS 0.02981f
C922 VDD.n397 VSS 0.02982f
C923 VDD.n398 VSS 0.03002f
C924 VDD.n399 VSS 0.03002f
C925 VDD.n400 VSS 0.03002f
C926 VDD.n401 VSS 0.03002f
C927 VDD.n402 VSS 0.02982f
C928 VDD.n403 VSS 0.02981f
C929 VDD.n404 VSS 0.02982f
C930 VDD.n405 VSS 0.03002f
C931 VDD.n406 VSS 0.03002f
C932 VDD.n407 VSS 0.03002f
C933 VDD.n408 VSS 0.03002f
C934 VDD.n409 VSS 0.02982f
C935 VDD.n410 VSS 0.02981f
C936 VDD.n411 VSS 0.02982f
C937 VDD.n412 VSS 0.03002f
C938 VDD.n413 VSS 0.03002f
C939 VDD.t603 VSS 0.12695f
C940 VDD.n414 VSS 0.0149f
C941 VDD.t611 VSS 0.12663f
C942 VDD.n415 VSS 0.03002f
C943 VDD.n416 VSS 0.03002f
C944 VDD.n417 VSS 0.02982f
C945 VDD.n418 VSS 0.03002f
C946 VDD.n419 VSS 0.02981f
C947 VDD.n420 VSS 0.03002f
C948 VDD.n421 VSS 0.02982f
C949 VDD.n422 VSS 0.03002f
C950 VDD.n423 VSS 0.03002f
C951 VDD.n424 VSS 0.02982f
C952 VDD.n425 VSS 0.03002f
C953 VDD.n426 VSS 0.02981f
C954 VDD.n427 VSS 0.03002f
C955 VDD.n428 VSS 0.02982f
C956 VDD.n429 VSS 0.03002f
C957 VDD.n430 VSS 0.03002f
C958 VDD.n431 VSS 0.02982f
C959 VDD.n432 VSS 0.03002f
C960 VDD.n433 VSS 0.02981f
C961 VDD.n434 VSS 0.03002f
C962 VDD.n435 VSS 0.02982f
C963 VDD.n436 VSS 0.03002f
C964 VDD.n437 VSS 0.03002f
C965 VDD.n438 VSS 0.02982f
C966 VDD.n439 VSS 0.03002f
C967 VDD.n440 VSS 0.02981f
C968 VDD.n441 VSS 0.0149f
C969 VDD.n442 VSS 0.02916f
C970 VDD.t610 VSS 0.12663f
C971 VDD.n443 VSS 0.01491f
C972 VDD.n444 VSS 0.04363f
C973 VDD.n445 VSS 0.04342f
C974 VDD.t602 VSS 0.12694f
C975 VDD.n446 VSS 0.02031f
C976 VDD.n447 VSS 0.04572f
C977 VDD.n448 VSS 0.11112f
C978 VDD.n449 VSS 0.0149f
C979 VDD.n450 VSS 0.03002f
C980 VDD.n451 VSS 0.03002f
C981 VDD.n452 VSS 0.02982f
C982 VDD.n453 VSS 0.02981f
C983 VDD.n454 VSS 0.02982f
C984 VDD.n455 VSS 0.03002f
C985 VDD.n456 VSS 0.03002f
C986 VDD.n457 VSS 0.03002f
C987 VDD.n458 VSS 0.03002f
C988 VDD.n459 VSS 0.02982f
C989 VDD.n460 VSS 0.02981f
C990 VDD.n461 VSS 0.02982f
C991 VDD.n462 VSS 0.03002f
C992 VDD.n463 VSS 0.03002f
C993 VDD.n464 VSS 0.03002f
C994 VDD.n465 VSS 0.03002f
C995 VDD.n466 VSS 0.02982f
C996 VDD.n467 VSS 0.02981f
C997 VDD.n468 VSS 0.02982f
C998 VDD.n469 VSS 0.03002f
C999 VDD.n470 VSS 0.03002f
C1000 VDD.t601 VSS 0.12695f
C1001 VDD.n471 VSS 0.0149f
C1002 VDD.t609 VSS 0.12663f
C1003 VDD.n472 VSS 0.03002f
C1004 VDD.n473 VSS 0.03002f
C1005 VDD.n474 VSS 0.02982f
C1006 VDD.n475 VSS 0.03002f
C1007 VDD.n476 VSS 0.02981f
C1008 VDD.n477 VSS 0.03002f
C1009 VDD.n478 VSS 0.02982f
C1010 VDD.n479 VSS 0.03002f
C1011 VDD.n480 VSS 0.03002f
C1012 VDD.n481 VSS 0.02982f
C1013 VDD.n482 VSS 0.03002f
C1014 VDD.n483 VSS 0.02981f
C1015 VDD.n484 VSS 0.03002f
C1016 VDD.n485 VSS 0.02982f
C1017 VDD.n486 VSS 0.03002f
C1018 VDD.n487 VSS 0.03002f
C1019 VDD.n488 VSS 0.02982f
C1020 VDD.n489 VSS 0.03002f
C1021 VDD.n490 VSS 0.02981f
C1022 VDD.n491 VSS 0.03002f
C1023 VDD.n492 VSS 0.02982f
C1024 VDD.n493 VSS 0.03002f
C1025 VDD.n494 VSS 0.03002f
C1026 VDD.n495 VSS 0.02982f
C1027 VDD.n496 VSS 0.03002f
C1028 VDD.n497 VSS 0.02981f
C1029 VDD.n498 VSS 0.0149f
C1030 VDD.n499 VSS 0.02916f
C1031 VDD.t608 VSS 0.12663f
C1032 VDD.n500 VSS 0.01491f
C1033 VDD.n501 VSS 0.04363f
C1034 VDD.n502 VSS 0.04342f
C1035 VDD.t600 VSS 0.12694f
C1036 VDD.n503 VSS 0.02031f
C1037 VDD.n504 VSS 0.04572f
C1038 VDD.n505 VSS 0.11112f
C1039 VDD.n506 VSS 0.0149f
C1040 VDD.n507 VSS 0.03002f
C1041 VDD.n508 VSS 0.03002f
C1042 VDD.n509 VSS 0.02982f
C1043 VDD.n510 VSS 0.02981f
C1044 VDD.n511 VSS 0.02982f
C1045 VDD.n512 VSS 0.03002f
C1046 VDD.n513 VSS 0.03002f
C1047 VDD.n514 VSS 0.03002f
C1048 VDD.n515 VSS 0.03002f
C1049 VDD.n516 VSS 0.02982f
C1050 VDD.n517 VSS 0.02981f
C1051 VDD.n518 VSS 0.02982f
C1052 VDD.n519 VSS 0.03002f
C1053 VDD.n520 VSS 0.03002f
C1054 VDD.n521 VSS 0.03002f
C1055 VDD.n522 VSS 0.03002f
C1056 VDD.n523 VSS 0.02982f
C1057 VDD.n524 VSS 0.02981f
C1058 VDD.n525 VSS 0.02982f
C1059 VDD.n526 VSS 0.03002f
C1060 VDD.n527 VSS 0.03002f
C1061 VDD.t599 VSS 0.12695f
C1062 VDD.n528 VSS 0.0149f
C1063 VDD.t607 VSS 0.12663f
C1064 VDD.n529 VSS 0.03002f
C1065 VDD.n530 VSS 0.03002f
C1066 VDD.n531 VSS 0.02982f
C1067 VDD.n532 VSS 0.03002f
C1068 VDD.n533 VSS 0.02981f
C1069 VDD.n534 VSS 0.03002f
C1070 VDD.n535 VSS 0.02982f
C1071 VDD.n536 VSS 0.03002f
C1072 VDD.n537 VSS 0.03002f
C1073 VDD.n538 VSS 0.02982f
C1074 VDD.n539 VSS 0.03002f
C1075 VDD.n540 VSS 0.02981f
C1076 VDD.n541 VSS 0.03002f
C1077 VDD.n542 VSS 0.02982f
C1078 VDD.n543 VSS 0.03002f
C1079 VDD.n544 VSS 0.03002f
C1080 VDD.n545 VSS 0.02982f
C1081 VDD.n546 VSS 0.03002f
C1082 VDD.n547 VSS 0.02981f
C1083 VDD.n548 VSS 0.03002f
C1084 VDD.n549 VSS 0.02982f
C1085 VDD.n550 VSS 0.03002f
C1086 VDD.n551 VSS 0.03002f
C1087 VDD.n552 VSS 0.02982f
C1088 VDD.n553 VSS 0.03002f
C1089 VDD.n554 VSS 0.02981f
C1090 VDD.n555 VSS 0.0149f
C1091 VDD.n556 VSS 0.02916f
C1092 VDD.t606 VSS 0.12663f
C1093 VDD.n557 VSS 0.01491f
C1094 VDD.n558 VSS 0.04363f
C1095 VDD.n559 VSS 0.04342f
C1096 VDD.t598 VSS 0.12694f
C1097 VDD.n560 VSS 0.02031f
C1098 VDD.n561 VSS 0.04572f
C1099 VDD.n562 VSS 0.04027f
C1100 VDD.n563 VSS 0.35083f
C1101 VDD.n564 VSS 0.65861f
C1102 VDD.n565 VSS 0.7053f
C1103 VDD.n566 VSS 1.46622f
C1104 VDD.n567 VSS 0.98865f
C1105 VDD.n568 VSS 0.59242f
C1106 VDD.t621 VSS 0.18241f
C1107 VDD.t620 VSS 0.18265f
C1108 VDD.n569 VSS 0.55374f
C1109 VDD.n570 VSS 1.06573f
C1110 VDD.n571 VSS 2.73112f
C1111 VDD.n572 VSS 1.48673f
C1112 VDD.n573 VSS 1.38007f
C1113 VDD.n574 VSS 0.13264f
C1114 VDD.n575 VSS 0.1078f
C1115 VDD.n576 VSS 0.13264f
C1116 VDD.n577 VSS 0.1078f
C1117 VDD.n578 VSS 0.07687f
C1118 VDD.n579 VSS 0.07853f
C1119 VDD.n580 VSS 0.1078f
C1120 VDD.n581 VSS 0.1078f
C1121 VDD.n582 VSS 0.07853f
C1122 VDD.n583 VSS 0.07687f
C1123 VDD.n584 VSS 0.74778f
C1124 VDD.n585 VSS 0.97594f
C1125 VDD.t605 VSS 0.12663f
C1126 VDD.n586 VSS 0.5907f
C1127 VDD.t597 VSS 0.12824f
C1128 VDD.n587 VSS 0.50337f
C1129 VDD.n588 VSS 0.39028f
C1130 VDD.n589 VSS 0.0743f
C1131 VDD.n590 VSS 0.06293f
C1132 VDD.n591 VSS 0.05649f
C1133 VDD.n592 VSS 0.05649f
C1134 VDD.n593 VSS 0.04119f
C1135 VDD.n594 VSS 0.19015f
C1136 VDD.n595 VSS 14.6939f
C1137 VDD.n596 VSS 0.00835f
C1138 VDD.t644 VSS 0.1872f
C1139 VDD.n597 VSS 0.03709f
C1140 VDD.t646 VSS 0.1872f
C1141 VDD.n598 VSS 0.03082f
C1142 VDD.n599 VSS 0.01657f
C1143 VDD.n600 VSS 0.01657f
C1144 VDD.t643 VSS 0.17231f
C1145 VDD.n601 VSS 0.062f
C1146 VDD.n602 VSS 0.16566f
C1147 VDD.t648 VSS 0.1872f
C1148 VDD.n603 VSS 0.04265f
C1149 VDD.t650 VSS 0.17231f
C1150 VDD.n604 VSS 0.06404f
C1151 VDD.n605 VSS 0.01161f
C1152 VDD.t642 VSS 6.47032f
C1153 VDD.n606 VSS 0.6217f
C1154 VDD.n607 VSS 0.00596f
C1155 VDD.n608 VSS 0.08051f
C1156 VDD.n609 VSS 1.5414f
C1157 VDD.n610 VSS 0.04119f
C1158 VDD.n611 VSS 0.04027f
C1159 VDD.n612 VSS 0.05649f
C1160 VDD.n613 VSS 0.05649f
C1161 VDD.n614 VSS 0.06293f
C1162 VDD.n615 VSS 0.0407f
C1163 VDD.n616 VSS 0.0743f
C1164 VDD.n617 VSS 0.39028f
C1165 VDD.n618 VSS 0.04572f
C1166 VDD.n619 VSS 0.04572f
C1167 VDD.n620 VSS 0.04572f
C1168 VDD.t70 VSS 0.12795f
C1169 VDD.t87 VSS 0.18241f
C1170 VDD.t86 VSS 0.18265f
C1171 VDD.n621 VSS 0.55374f
C1172 VDD.n622 VSS 0.0149f
C1173 VDD.n623 VSS 0.01491f
C1174 VDD.n624 VSS 0.03002f
C1175 VDD.n625 VSS 0.03002f
C1176 VDD.n626 VSS 0.03002f
C1177 VDD.n627 VSS 0.03002f
C1178 VDD.n628 VSS 0.02982f
C1179 VDD.n629 VSS 0.02981f
C1180 VDD.n630 VSS 0.02982f
C1181 VDD.n631 VSS 0.03002f
C1182 VDD.n632 VSS 0.03002f
C1183 VDD.n633 VSS 0.03002f
C1184 VDD.n634 VSS 0.03002f
C1185 VDD.n635 VSS 0.02982f
C1186 VDD.n636 VSS 0.03002f
C1187 VDD.n637 VSS 0.02982f
C1188 VDD.n638 VSS 0.02981f
C1189 VDD.n639 VSS 0.02982f
C1190 VDD.n640 VSS 0.03002f
C1191 VDD.n641 VSS 0.03002f
C1192 VDD.n642 VSS 0.03002f
C1193 VDD.n643 VSS 0.03002f
C1194 VDD.n644 VSS 0.02982f
C1195 VDD.n645 VSS 0.02981f
C1196 VDD.n646 VSS 0.02982f
C1197 VDD.n647 VSS 0.03002f
C1198 VDD.n648 VSS 0.0149f
C1199 VDD.n649 VSS 0.02031f
C1200 VDD.n650 VSS 0.03002f
C1201 VDD.n651 VSS 0.03002f
C1202 VDD.n652 VSS 0.02982f
C1203 VDD.n653 VSS 0.02981f
C1204 VDD.n654 VSS 0.02982f
C1205 VDD.n655 VSS 0.03002f
C1206 VDD.n656 VSS 0.03002f
C1207 VDD.n657 VSS 0.03002f
C1208 VDD.n658 VSS 0.03002f
C1209 VDD.n659 VSS 0.02982f
C1210 VDD.n660 VSS 0.02981f
C1211 VDD.n661 VSS 0.0149f
C1212 VDD.n662 VSS 0.02982f
C1213 VDD.n663 VSS 0.03002f
C1214 VDD.n664 VSS 0.03002f
C1215 VDD.n665 VSS 0.03002f
C1216 VDD.n666 VSS 0.03002f
C1217 VDD.n667 VSS 0.02982f
C1218 VDD.n668 VSS 0.02981f
C1219 VDD.n669 VSS 0.02982f
C1220 VDD.n670 VSS 0.03002f
C1221 VDD.n671 VSS 0.03002f
C1222 VDD.t72 VSS 0.12695f
C1223 VDD.n672 VSS 0.11112f
C1224 VDD.t71 VSS 0.12694f
C1225 VDD.n673 VSS 0.04342f
C1226 VDD.n674 VSS 0.04363f
C1227 VDD.t80 VSS 0.12663f
C1228 VDD.n675 VSS 0.03002f
C1229 VDD.n676 VSS 0.02981f
C1230 VDD.t79 VSS 0.12663f
C1231 VDD.n677 VSS 0.02916f
C1232 VDD.t89 VSS 0.18241f
C1233 VDD.t88 VSS 0.18265f
C1234 VDD.n678 VSS 0.55374f
C1235 VDD.n679 VSS 0.22831f
C1236 VDD.n680 VSS 0.0149f
C1237 VDD.n681 VSS 0.01491f
C1238 VDD.n682 VSS 0.03002f
C1239 VDD.n683 VSS 0.03002f
C1240 VDD.n684 VSS 0.03002f
C1241 VDD.n685 VSS 0.03002f
C1242 VDD.n686 VSS 0.02982f
C1243 VDD.n687 VSS 0.02981f
C1244 VDD.n688 VSS 0.02982f
C1245 VDD.n689 VSS 0.03002f
C1246 VDD.n690 VSS 0.03002f
C1247 VDD.n691 VSS 0.03002f
C1248 VDD.n692 VSS 0.03002f
C1249 VDD.n693 VSS 0.02982f
C1250 VDD.n694 VSS 0.03002f
C1251 VDD.n695 VSS 0.02982f
C1252 VDD.n696 VSS 0.02981f
C1253 VDD.n697 VSS 0.02982f
C1254 VDD.n698 VSS 0.03002f
C1255 VDD.n699 VSS 0.03002f
C1256 VDD.n700 VSS 0.03002f
C1257 VDD.n701 VSS 0.03002f
C1258 VDD.n702 VSS 0.02982f
C1259 VDD.n703 VSS 0.02981f
C1260 VDD.n704 VSS 0.02982f
C1261 VDD.n705 VSS 0.03002f
C1262 VDD.n706 VSS 0.0149f
C1263 VDD.n707 VSS 0.02031f
C1264 VDD.n708 VSS 0.03002f
C1265 VDD.n709 VSS 0.03002f
C1266 VDD.n710 VSS 0.02982f
C1267 VDD.n711 VSS 0.02981f
C1268 VDD.n712 VSS 0.02982f
C1269 VDD.n713 VSS 0.03002f
C1270 VDD.n714 VSS 0.03002f
C1271 VDD.n715 VSS 0.03002f
C1272 VDD.n716 VSS 0.03002f
C1273 VDD.n717 VSS 0.02982f
C1274 VDD.n718 VSS 0.02981f
C1275 VDD.n719 VSS 0.0149f
C1276 VDD.n720 VSS 0.02982f
C1277 VDD.n721 VSS 0.03002f
C1278 VDD.n722 VSS 0.03002f
C1279 VDD.n723 VSS 0.03002f
C1280 VDD.n724 VSS 0.03002f
C1281 VDD.n725 VSS 0.02982f
C1282 VDD.n726 VSS 0.02981f
C1283 VDD.n727 VSS 0.02982f
C1284 VDD.n728 VSS 0.03002f
C1285 VDD.n729 VSS 0.03002f
C1286 VDD.t74 VSS 0.12695f
C1287 VDD.n730 VSS 0.11112f
C1288 VDD.t73 VSS 0.12694f
C1289 VDD.n731 VSS 0.04342f
C1290 VDD.n732 VSS 0.04363f
C1291 VDD.t82 VSS 0.12663f
C1292 VDD.n733 VSS 0.03002f
C1293 VDD.n734 VSS 0.02981f
C1294 VDD.t81 VSS 0.12663f
C1295 VDD.n735 VSS 0.02916f
C1296 VDD.t91 VSS 0.18241f
C1297 VDD.t90 VSS 0.18265f
C1298 VDD.n736 VSS 0.55374f
C1299 VDD.n737 VSS 0.22831f
C1300 VDD.n738 VSS 0.0149f
C1301 VDD.n739 VSS 0.01491f
C1302 VDD.n740 VSS 0.03002f
C1303 VDD.n741 VSS 0.03002f
C1304 VDD.n742 VSS 0.03002f
C1305 VDD.n743 VSS 0.03002f
C1306 VDD.n744 VSS 0.02982f
C1307 VDD.n745 VSS 0.02981f
C1308 VDD.n746 VSS 0.02982f
C1309 VDD.n747 VSS 0.03002f
C1310 VDD.n748 VSS 0.03002f
C1311 VDD.n749 VSS 0.03002f
C1312 VDD.n750 VSS 0.03002f
C1313 VDD.n751 VSS 0.02982f
C1314 VDD.n752 VSS 0.03002f
C1315 VDD.n753 VSS 0.02982f
C1316 VDD.n754 VSS 0.02981f
C1317 VDD.n755 VSS 0.02982f
C1318 VDD.n756 VSS 0.03002f
C1319 VDD.n757 VSS 0.03002f
C1320 VDD.n758 VSS 0.03002f
C1321 VDD.n759 VSS 0.03002f
C1322 VDD.n760 VSS 0.02982f
C1323 VDD.n761 VSS 0.02981f
C1324 VDD.n762 VSS 0.02982f
C1325 VDD.n763 VSS 0.03002f
C1326 VDD.n764 VSS 0.0149f
C1327 VDD.n765 VSS 0.02031f
C1328 VDD.n766 VSS 0.03002f
C1329 VDD.n767 VSS 0.03002f
C1330 VDD.n768 VSS 0.02982f
C1331 VDD.n769 VSS 0.02981f
C1332 VDD.n770 VSS 0.02982f
C1333 VDD.n771 VSS 0.03002f
C1334 VDD.n772 VSS 0.03002f
C1335 VDD.n773 VSS 0.03002f
C1336 VDD.n774 VSS 0.03002f
C1337 VDD.n775 VSS 0.02982f
C1338 VDD.n776 VSS 0.02981f
C1339 VDD.n777 VSS 0.0149f
C1340 VDD.n778 VSS 0.02982f
C1341 VDD.n779 VSS 0.03002f
C1342 VDD.n780 VSS 0.03002f
C1343 VDD.n781 VSS 0.03002f
C1344 VDD.n782 VSS 0.03002f
C1345 VDD.n783 VSS 0.02982f
C1346 VDD.n784 VSS 0.02981f
C1347 VDD.n785 VSS 0.02982f
C1348 VDD.n786 VSS 0.03002f
C1349 VDD.n787 VSS 0.03002f
C1350 VDD.t76 VSS 0.12695f
C1351 VDD.n788 VSS 0.11112f
C1352 VDD.t75 VSS 0.12694f
C1353 VDD.n789 VSS 0.04342f
C1354 VDD.n790 VSS 0.04363f
C1355 VDD.t84 VSS 0.12663f
C1356 VDD.n791 VSS 0.03002f
C1357 VDD.n792 VSS 0.02981f
C1358 VDD.t83 VSS 0.12663f
C1359 VDD.n793 VSS 0.02916f
C1360 VDD.t93 VSS 0.18241f
C1361 VDD.t92 VSS 0.18265f
C1362 VDD.n794 VSS 0.55374f
C1363 VDD.n795 VSS 0.22831f
C1364 VDD.n797 VSS 0.1078f
C1365 VDD.n798 VSS 0.1078f
C1366 VDD.n799 VSS 0.13264f
C1367 VDD.n800 VSS 0.13264f
C1368 VDD.t85 VSS 0.12663f
C1369 VDD.t77 VSS 0.12824f
C1370 VDD.n801 VSS 0.50337f
C1371 VDD.n802 VSS 0.5907f
C1372 VDD.t94 VSS 0.31906f
C1373 VDD.n803 VSS 0.97594f
C1374 VDD.n804 VSS 0.15665f
C1375 VDD.n805 VSS 0.07774f
C1376 VDD.n806 VSS 0.07853f
C1377 VDD.n807 VSS 0.1078f
C1378 VDD.n808 VSS 0.1078f
C1379 VDD.n809 VSS 0.07853f
C1380 VDD.n810 VSS 0.07687f
C1381 VDD.n811 VSS 0.74778f
C1382 VDD.n812 VSS 1.38007f
C1383 VDD.n813 VSS 1.48673f
C1384 VDD.n814 VSS 2.73359f
C1385 VDD.n815 VSS 1.06327f
C1386 VDD.t78 VSS 0.12663f
C1387 VDD.n816 VSS 0.59242f
C1388 VDD.n817 VSS 0.98824f
C1389 VDD.n818 VSS 1.46663f
C1390 VDD.n819 VSS 0.7053f
C1391 VDD.n820 VSS 0.65861f
C1392 VDD.n821 VSS 0.35083f
C1393 VDD.n823 VSS 0.06293f
C1394 VDD.n824 VSS 0.05649f
C1395 VDD.n825 VSS 0.05649f
C1396 VDD.n826 VSS 0.04119f
C1397 VDD.n827 VSS 0.19015f
C1398 VDD.n828 VSS 14.6939f
C1399 VDD.n829 VSS 5.15803f
C1400 VDD.n830 VSS 0.01252f
C1401 VDD.t623 VSS 0.10679f
C1402 VDD.t624 VSS 0.10679f
C1403 VDD.t625 VSS 0.12011f
C1404 VDD.n831 VSS 0.08427f
C1405 VDD.n832 VSS 0.04982f
C1406 VDD.t622 VSS 10.702f
C1407 VDD.n833 VSS 0.97901f
C1408 VDD.t628 VSS 0.10679f
C1409 VDD.t630 VSS 0.10679f
C1410 VDD.t632 VSS 0.12011f
C1411 VDD.n834 VSS 0.08427f
C1412 VDD.n835 VSS 0.04982f
C1413 VDD.n836 VSS 0.04804f
C1414 VDD.n837 VSS 0.39107f
C1415 VDD.n838 VSS 0.05295f
C1416 VDD.n839 VSS 0.08502f
C1417 VDD.n840 VSS 2.66595f
C1418 VDD.n841 VSS 5.15272f
C1419 VDD.n842 VSS 28.8927f
C1420 VDD.n843 VSS 24.0914f
C1421 VDD.n844 VSS 0.01278f
C1422 VDD.n845 VSS 0.02556f
C1423 VDD.n846 VSS 0.02556f
C1424 VDD.n847 VSS 0.07151f
C1425 VDD.n848 VSS 0.02556f
C1426 VDD.n849 VSS 0.02556f
C1427 VDD.n850 VSS 0.02064f
C1428 VDD.n851 VSS 0.00514f
C1429 VDD.n852 VSS 0.00514f
C1430 VDD.n853 VSS 0.00514f
C1431 VDD.n854 VSS 0.00514f
C1432 VDD.n855 VSS 0.00514f
C1433 VDD.n856 VSS 0.00514f
C1434 VDD.n857 VSS 0.00514f
C1435 VDD.n858 VSS 0.00514f
C1436 VDD.n859 VSS 0.00514f
C1437 VDD.n860 VSS 0.00514f
C1438 VDD.n861 VSS 0.00514f
C1439 VDD.n862 VSS 0.00514f
C1440 VDD.t594 VSS 0.0194f
C1441 VDD.n863 VSS 0.00983f
C1442 VDD.t592 VSS 0.0194f
C1443 VDD.n864 VSS 0.00983f
C1444 VDD.t590 VSS 0.0194f
C1445 VDD.n865 VSS 0.00983f
C1446 VDD.t588 VSS 0.0194f
C1447 VDD.n866 VSS 0.00983f
C1448 VDD.t567 VSS 0.01735f
C1449 VDD.n867 VSS 0.00646f
C1450 VDD.n868 VSS 0.01152f
C1451 VDD.t568 VSS 0.01939f
C1452 VDD.t558 VSS 0.01939f
C1453 VDD.t548 VSS 0.01939f
C1454 VDD.n869 VSS 0.00647f
C1455 VDD.n870 VSS 0.01152f
C1456 VDD.t527 VSS 0.01735f
C1457 VDD.n871 VSS 0.00646f
C1458 VDD.n872 VSS 0.01152f
C1459 VDD.t528 VSS 0.01939f
C1460 VDD.t518 VSS 0.01939f
C1461 VDD.t508 VSS 0.01939f
C1462 VDD.n873 VSS 0.00647f
C1463 VDD.n874 VSS 0.01152f
C1464 VDD.t487 VSS 0.01735f
C1465 VDD.n875 VSS 0.00646f
C1466 VDD.n876 VSS 0.01152f
C1467 VDD.t488 VSS 0.01939f
C1468 VDD.t478 VSS 0.01939f
C1469 VDD.t468 VSS 0.01939f
C1470 VDD.n877 VSS 0.00647f
C1471 VDD.n878 VSS 0.01152f
C1472 VDD.t447 VSS 0.01735f
C1473 VDD.n879 VSS 0.00646f
C1474 VDD.n880 VSS 0.01152f
C1475 VDD.t448 VSS 0.01939f
C1476 VDD.t438 VSS 0.01939f
C1477 VDD.t428 VSS 0.01939f
C1478 VDD.n881 VSS 0.00647f
C1479 VDD.n882 VSS 0.01152f
C1480 VDD.t407 VSS 0.01735f
C1481 VDD.n883 VSS 0.00646f
C1482 VDD.n884 VSS 0.01152f
C1483 VDD.t408 VSS 0.01939f
C1484 VDD.t398 VSS 0.01939f
C1485 VDD.t388 VSS 0.01939f
C1486 VDD.n885 VSS 0.00647f
C1487 VDD.n886 VSS 0.01152f
C1488 VDD.t367 VSS 0.01735f
C1489 VDD.n887 VSS 0.00646f
C1490 VDD.n888 VSS 0.01152f
C1491 VDD.t368 VSS 0.01939f
C1492 VDD.t358 VSS 0.01939f
C1493 VDD.t348 VSS 0.01996f
C1494 VDD.n889 VSS 0.01152f
C1495 VDD.t352 VSS 0.01996f
C1496 VDD.t382 VSS 0.01939f
C1497 VDD.n890 VSS 0.00663f
C1498 VDD.t374 VSS 0.01939f
C1499 VDD.t364 VSS 0.01939f
C1500 VDD.t354 VSS 0.01996f
C1501 VDD.n891 VSS 0.01308f
C1502 VDD.n892 VSS 0.00663f
C1503 VDD.n893 VSS 0.00647f
C1504 VDD.t404 VSS 0.01939f
C1505 VDD.n894 VSS 0.00663f
C1506 VDD.t392 VSS 0.01939f
C1507 VDD.n895 VSS 0.00647f
C1508 VDD.t422 VSS 0.01939f
C1509 VDD.n896 VSS 0.00663f
C1510 VDD.t414 VSS 0.01939f
C1511 VDD.n897 VSS 0.00646f
C1512 VDD.t444 VSS 0.01939f
C1513 VDD.n898 VSS 0.00663f
C1514 VDD.t432 VSS 0.01939f
C1515 VDD.n899 VSS 0.00647f
C1516 VDD.t462 VSS 0.01939f
C1517 VDD.n900 VSS 0.00663f
C1518 VDD.t454 VSS 0.01939f
C1519 VDD.n901 VSS 0.00646f
C1520 VDD.t484 VSS 0.01939f
C1521 VDD.n902 VSS 0.00663f
C1522 VDD.t472 VSS 0.01939f
C1523 VDD.n903 VSS 0.00647f
C1524 VDD.t502 VSS 0.01939f
C1525 VDD.n904 VSS 0.00663f
C1526 VDD.t494 VSS 0.01939f
C1527 VDD.n905 VSS 0.00646f
C1528 VDD.t524 VSS 0.01939f
C1529 VDD.n906 VSS 0.00663f
C1530 VDD.t512 VSS 0.01939f
C1531 VDD.n907 VSS 0.00647f
C1532 VDD.t542 VSS 0.01939f
C1533 VDD.n908 VSS 0.00663f
C1534 VDD.t534 VSS 0.01939f
C1535 VDD.n909 VSS 0.00646f
C1536 VDD.t564 VSS 0.01939f
C1537 VDD.n910 VSS 0.00663f
C1538 VDD.t552 VSS 0.01939f
C1539 VDD.n911 VSS 0.00647f
C1540 VDD.t582 VSS 0.01939f
C1541 VDD.n912 VSS 0.00633f
C1542 VDD.t574 VSS 0.01939f
C1543 VDD.n913 VSS 0.00646f
C1544 VDD.t584 VSS 0.01939f
C1545 VDD.n914 VSS 0.00633f
C1546 VDD.n915 VSS 0.00781f
C1547 VDD.n916 VSS 0.01152f
C1548 VDD.n917 VSS 0.01152f
C1549 VDD.n918 VSS 0.00781f
C1550 VDD.t572 VSS 0.01939f
C1551 VDD.n919 VSS 0.00647f
C1552 VDD.t562 VSS 0.01939f
C1553 VDD.n920 VSS 0.00663f
C1554 VDD.n921 VSS 0.00781f
C1555 VDD.n922 VSS 0.01152f
C1556 VDD.n923 VSS 0.01152f
C1557 VDD.n924 VSS 0.00781f
C1558 VDD.t554 VSS 0.01939f
C1559 VDD.n925 VSS 0.00646f
C1560 VDD.t544 VSS 0.01939f
C1561 VDD.n926 VSS 0.00663f
C1562 VDD.n927 VSS 0.00781f
C1563 VDD.n928 VSS 0.01152f
C1564 VDD.n929 VSS 0.01152f
C1565 VDD.n930 VSS 0.00781f
C1566 VDD.t532 VSS 0.01939f
C1567 VDD.n931 VSS 0.00647f
C1568 VDD.t522 VSS 0.01939f
C1569 VDD.n932 VSS 0.00663f
C1570 VDD.n933 VSS 0.00781f
C1571 VDD.n934 VSS 0.01152f
C1572 VDD.n935 VSS 0.01152f
C1573 VDD.n936 VSS 0.00781f
C1574 VDD.t514 VSS 0.01939f
C1575 VDD.n937 VSS 0.00646f
C1576 VDD.t504 VSS 0.01939f
C1577 VDD.n938 VSS 0.00663f
C1578 VDD.n939 VSS 0.00781f
C1579 VDD.n940 VSS 0.01152f
C1580 VDD.n941 VSS 0.01152f
C1581 VDD.n942 VSS 0.00781f
C1582 VDD.t492 VSS 0.01939f
C1583 VDD.n943 VSS 0.00647f
C1584 VDD.t482 VSS 0.01939f
C1585 VDD.n944 VSS 0.00663f
C1586 VDD.n945 VSS 0.00781f
C1587 VDD.n946 VSS 0.01152f
C1588 VDD.n947 VSS 0.01152f
C1589 VDD.n948 VSS 0.00781f
C1590 VDD.t474 VSS 0.01939f
C1591 VDD.n949 VSS 0.00646f
C1592 VDD.t464 VSS 0.01939f
C1593 VDD.n950 VSS 0.00663f
C1594 VDD.n951 VSS 0.00781f
C1595 VDD.n952 VSS 0.01152f
C1596 VDD.n953 VSS 0.01152f
C1597 VDD.n954 VSS 0.00781f
C1598 VDD.t452 VSS 0.01939f
C1599 VDD.n955 VSS 0.00647f
C1600 VDD.t442 VSS 0.01939f
C1601 VDD.n956 VSS 0.00663f
C1602 VDD.n957 VSS 0.00781f
C1603 VDD.n958 VSS 0.01152f
C1604 VDD.n959 VSS 0.01152f
C1605 VDD.n960 VSS 0.00781f
C1606 VDD.t434 VSS 0.01939f
C1607 VDD.n961 VSS 0.00646f
C1608 VDD.t424 VSS 0.01939f
C1609 VDD.n962 VSS 0.00663f
C1610 VDD.n963 VSS 0.00781f
C1611 VDD.n964 VSS 0.01152f
C1612 VDD.n965 VSS 0.01152f
C1613 VDD.n966 VSS 0.00781f
C1614 VDD.t412 VSS 0.01939f
C1615 VDD.n967 VSS 0.00647f
C1616 VDD.t402 VSS 0.01939f
C1617 VDD.n968 VSS 0.00663f
C1618 VDD.n969 VSS 0.00781f
C1619 VDD.n970 VSS 0.01152f
C1620 VDD.n971 VSS 0.01152f
C1621 VDD.n972 VSS 0.00781f
C1622 VDD.t394 VSS 0.01939f
C1623 VDD.n973 VSS 0.00646f
C1624 VDD.t384 VSS 0.01939f
C1625 VDD.n974 VSS 0.00663f
C1626 VDD.n975 VSS 0.00781f
C1627 VDD.n976 VSS 0.01152f
C1628 VDD.n977 VSS 0.01152f
C1629 VDD.n978 VSS 0.00781f
C1630 VDD.t372 VSS 0.01939f
C1631 VDD.n979 VSS 0.00647f
C1632 VDD.t362 VSS 0.01939f
C1633 VDD.n980 VSS 0.00663f
C1634 VDD.n981 VSS 0.01308f
C1635 VDD.n982 VSS 0.01152f
C1636 VDD.t350 VSS 0.01996f
C1637 VDD.t580 VSS 0.01939f
C1638 VDD.n983 VSS 0.00633f
C1639 VDD.n984 VSS 0.00781f
C1640 VDD.t570 VSS 0.01939f
C1641 VDD.n985 VSS 0.00646f
C1642 VDD.t560 VSS 0.01939f
C1643 VDD.n986 VSS 0.00663f
C1644 VDD.n987 VSS 0.00781f
C1645 VDD.t550 VSS 0.01939f
C1646 VDD.n988 VSS 0.00646f
C1647 VDD.t540 VSS 0.01939f
C1648 VDD.n989 VSS 0.00663f
C1649 VDD.n990 VSS 0.00781f
C1650 VDD.t530 VSS 0.01939f
C1651 VDD.n991 VSS 0.00646f
C1652 VDD.t520 VSS 0.01939f
C1653 VDD.n992 VSS 0.00663f
C1654 VDD.n993 VSS 0.00781f
C1655 VDD.t510 VSS 0.01939f
C1656 VDD.n994 VSS 0.00646f
C1657 VDD.t500 VSS 0.01939f
C1658 VDD.n995 VSS 0.00663f
C1659 VDD.n996 VSS 0.00781f
C1660 VDD.t490 VSS 0.01939f
C1661 VDD.n997 VSS 0.00646f
C1662 VDD.t480 VSS 0.01939f
C1663 VDD.n998 VSS 0.00663f
C1664 VDD.n999 VSS 0.00781f
C1665 VDD.t470 VSS 0.01939f
C1666 VDD.n1000 VSS 0.00646f
C1667 VDD.t460 VSS 0.01939f
C1668 VDD.n1001 VSS 0.00663f
C1669 VDD.n1002 VSS 0.00781f
C1670 VDD.t450 VSS 0.01939f
C1671 VDD.n1003 VSS 0.00646f
C1672 VDD.t440 VSS 0.01939f
C1673 VDD.n1004 VSS 0.00663f
C1674 VDD.n1005 VSS 0.00781f
C1675 VDD.t430 VSS 0.01939f
C1676 VDD.n1006 VSS 0.00646f
C1677 VDD.t420 VSS 0.01939f
C1678 VDD.n1007 VSS 0.00663f
C1679 VDD.n1008 VSS 0.00781f
C1680 VDD.t410 VSS 0.01939f
C1681 VDD.n1009 VSS 0.00646f
C1682 VDD.t400 VSS 0.01939f
C1683 VDD.n1010 VSS 0.00663f
C1684 VDD.n1011 VSS 0.00781f
C1685 VDD.t390 VSS 0.01939f
C1686 VDD.n1012 VSS 0.00647f
C1687 VDD.t380 VSS 0.01939f
C1688 VDD.n1013 VSS 0.00663f
C1689 VDD.n1014 VSS 0.00781f
C1690 VDD.t370 VSS 0.01939f
C1691 VDD.n1015 VSS 0.00647f
C1692 VDD.t360 VSS 0.01939f
C1693 VDD.n1016 VSS 0.00663f
C1694 VDD.n1017 VSS 0.01308f
C1695 VDD.n1018 VSS 0.01152f
C1696 VDD.t347 VSS 0.01791f
C1697 VDD.t357 VSS 0.01735f
C1698 VDD.n1019 VSS 0.00662f
C1699 VDD.n1020 VSS 0.01362f
C1700 VDD.n1021 VSS 0.01558f
C1701 VDD.n1022 VSS 0.01308f
C1702 VDD.n1023 VSS 0.00663f
C1703 VDD.n1024 VSS 0.00647f
C1704 VDD.t378 VSS 0.01939f
C1705 VDD.n1025 VSS 0.00663f
C1706 VDD.n1026 VSS 0.00781f
C1707 VDD.n1027 VSS 0.01558f
C1708 VDD.n1028 VSS 0.00835f
C1709 VDD.t377 VSS 0.01735f
C1710 VDD.n1029 VSS 0.00662f
C1711 VDD.t387 VSS 0.01735f
C1712 VDD.n1030 VSS 0.00646f
C1713 VDD.t397 VSS 0.01735f
C1714 VDD.n1031 VSS 0.00662f
C1715 VDD.n1032 VSS 0.00835f
C1716 VDD.n1033 VSS 0.01558f
C1717 VDD.n1034 VSS 0.00781f
C1718 VDD.n1035 VSS 0.00663f
C1719 VDD.n1036 VSS 0.00647f
C1720 VDD.t418 VSS 0.01939f
C1721 VDD.n1037 VSS 0.00663f
C1722 VDD.n1038 VSS 0.00781f
C1723 VDD.n1039 VSS 0.01558f
C1724 VDD.n1040 VSS 0.00835f
C1725 VDD.t417 VSS 0.01735f
C1726 VDD.n1041 VSS 0.00662f
C1727 VDD.t427 VSS 0.01735f
C1728 VDD.n1042 VSS 0.00646f
C1729 VDD.t437 VSS 0.01735f
C1730 VDD.n1043 VSS 0.00662f
C1731 VDD.n1044 VSS 0.00835f
C1732 VDD.n1045 VSS 0.01558f
C1733 VDD.n1046 VSS 0.00781f
C1734 VDD.n1047 VSS 0.00663f
C1735 VDD.n1048 VSS 0.00647f
C1736 VDD.t458 VSS 0.01939f
C1737 VDD.n1049 VSS 0.00663f
C1738 VDD.n1050 VSS 0.00781f
C1739 VDD.n1051 VSS 0.01558f
C1740 VDD.n1052 VSS 0.00835f
C1741 VDD.t457 VSS 0.01735f
C1742 VDD.n1053 VSS 0.00662f
C1743 VDD.t467 VSS 0.01735f
C1744 VDD.n1054 VSS 0.00646f
C1745 VDD.t477 VSS 0.01735f
C1746 VDD.n1055 VSS 0.00662f
C1747 VDD.n1056 VSS 0.00835f
C1748 VDD.n1057 VSS 0.01558f
C1749 VDD.n1058 VSS 0.00781f
C1750 VDD.n1059 VSS 0.00663f
C1751 VDD.n1060 VSS 0.00647f
C1752 VDD.t498 VSS 0.01939f
C1753 VDD.n1061 VSS 0.00663f
C1754 VDD.n1062 VSS 0.00781f
C1755 VDD.n1063 VSS 0.01558f
C1756 VDD.n1064 VSS 0.00835f
C1757 VDD.t497 VSS 0.01735f
C1758 VDD.n1065 VSS 0.00662f
C1759 VDD.t507 VSS 0.01735f
C1760 VDD.n1066 VSS 0.00646f
C1761 VDD.t517 VSS 0.01735f
C1762 VDD.n1067 VSS 0.00662f
C1763 VDD.n1068 VSS 0.00835f
C1764 VDD.n1069 VSS 0.01558f
C1765 VDD.n1070 VSS 0.00781f
C1766 VDD.n1071 VSS 0.00663f
C1767 VDD.n1072 VSS 0.00647f
C1768 VDD.t538 VSS 0.01939f
C1769 VDD.n1073 VSS 0.00663f
C1770 VDD.n1074 VSS 0.00781f
C1771 VDD.n1075 VSS 0.01558f
C1772 VDD.n1076 VSS 0.00835f
C1773 VDD.t537 VSS 0.01735f
C1774 VDD.n1077 VSS 0.00662f
C1775 VDD.t547 VSS 0.01735f
C1776 VDD.n1078 VSS 0.00646f
C1777 VDD.t557 VSS 0.01735f
C1778 VDD.n1079 VSS 0.00662f
C1779 VDD.n1080 VSS 0.00835f
C1780 VDD.n1081 VSS 0.01558f
C1781 VDD.n1082 VSS 0.00781f
C1782 VDD.n1083 VSS 0.00663f
C1783 VDD.n1084 VSS 0.00646f
C1784 VDD.t578 VSS 0.01939f
C1785 VDD.n1085 VSS 0.00633f
C1786 VDD.n1086 VSS 0.00781f
C1787 VDD.n1087 VSS 0.01558f
C1788 VDD.n1088 VSS 0.00835f
C1789 VDD.t577 VSS 0.01735f
C1790 VDD.n1089 VSS 0.00633f
C1791 VDD.t587 VSS 0.01736f
C1792 VDD.n1090 VSS 0.01105f
C1793 VDD.n1091 VSS 0.02472f
C1794 VDD.n1092 VSS 0.01526f
C1795 VDD.n1093 VSS 0.01526f
C1796 VDD.n1094 VSS 0.01526f
C1797 VDD.t586 VSS 0.01735f
C1798 VDD.t576 VSS 0.01735f
C1799 VDD.t566 VSS 0.01735f
C1800 VDD.t556 VSS 0.01735f
C1801 VDD.t546 VSS 0.01735f
C1802 VDD.t536 VSS 0.01735f
C1803 VDD.t526 VSS 0.01735f
C1804 VDD.t516 VSS 0.01735f
C1805 VDD.t506 VSS 0.01735f
C1806 VDD.t496 VSS 0.01735f
C1807 VDD.t486 VSS 0.01735f
C1808 VDD.t476 VSS 0.01735f
C1809 VDD.t466 VSS 0.01735f
C1810 VDD.t456 VSS 0.01735f
C1811 VDD.t446 VSS 0.01735f
C1812 VDD.t436 VSS 0.01735f
C1813 VDD.t426 VSS 0.01735f
C1814 VDD.t416 VSS 0.01735f
C1815 VDD.t406 VSS 0.01735f
C1816 VDD.t396 VSS 0.01735f
C1817 VDD.t386 VSS 0.01735f
C1818 VDD.t376 VSS 0.01735f
C1819 VDD.t366 VSS 0.01735f
C1820 VDD.t356 VSS 0.01791f
C1821 VDD.n1095 VSS 0.01308f
C1822 VDD.n1096 VSS 0.00663f
C1823 VDD.n1097 VSS 0.00647f
C1824 VDD.n1098 VSS 0.00781f
C1825 VDD.n1099 VSS 0.00663f
C1826 VDD.n1100 VSS 0.00647f
C1827 VDD.n1101 VSS 0.00781f
C1828 VDD.n1102 VSS 0.00663f
C1829 VDD.n1103 VSS 0.00647f
C1830 VDD.n1104 VSS 0.00781f
C1831 VDD.n1105 VSS 0.00663f
C1832 VDD.n1106 VSS 0.00647f
C1833 VDD.n1107 VSS 0.00781f
C1834 VDD.n1108 VSS 0.00663f
C1835 VDD.n1109 VSS 0.00647f
C1836 VDD.n1110 VSS 0.00781f
C1837 VDD.n1111 VSS 0.00663f
C1838 VDD.n1112 VSS 0.00647f
C1839 VDD.n1113 VSS 0.00781f
C1840 VDD.n1114 VSS 0.00663f
C1841 VDD.n1115 VSS 0.00647f
C1842 VDD.n1116 VSS 0.00781f
C1843 VDD.n1117 VSS 0.00663f
C1844 VDD.n1118 VSS 0.00647f
C1845 VDD.n1119 VSS 0.00781f
C1846 VDD.n1120 VSS 0.00663f
C1847 VDD.n1121 VSS 0.00647f
C1848 VDD.n1122 VSS 0.00781f
C1849 VDD.n1123 VSS 0.00663f
C1850 VDD.n1124 VSS 0.00647f
C1851 VDD.n1125 VSS 0.00781f
C1852 VDD.n1126 VSS 0.00663f
C1853 VDD.n1127 VSS 0.00647f
C1854 VDD.n1128 VSS 0.00781f
C1855 VDD.n1129 VSS 0.00633f
C1856 VDD.t596 VSS 0.01736f
C1857 VDD.n1130 VSS 0.00983f
C1858 VDD.n1131 VSS 0.07782f
C1859 VDD.n1132 VSS 0.53862f
C1860 VDD.n1133 VSS 0.07542f
C1861 VDD.n1134 VSS 0.23538f
C1862 VDD.n1135 VSS 0.32671f
C1863 VDD.n1136 VSS 0.47308f
C1864 VDD.n1137 VSS 0.47308f
C1865 VDD.n1138 VSS 0.47308f
C1866 VDD.n1139 VSS 0.47308f
C1867 VDD.n1140 VSS 0.47308f
C1868 VDD.n1141 VSS 0.47308f
C1869 VDD.n1142 VSS 0.43174f
C1870 VDD.n1143 VSS 0.07401f
C1871 VDD.n1144 VSS 0.23538f
C1872 VDD.n1145 VSS 0.27904f
C1873 VDD.n1146 VSS 0.47308f
C1874 VDD.n1147 VSS 0.977f
C1875 VDD.n1148 VSS 0.66774f
C1876 VDD.n1149 VSS 0.07151f
C1877 VDD.n1150 VSS 0.02556f
C1878 VDD.n1151 VSS 0.02556f
C1879 VDD.n1152 VSS 0.0218f
C1880 VDD.n1153 VSS 0.07019f
C1881 VDD.n1154 VSS 0.01917f
C1882 VDD.n1155 VSS 0.02556f
C1883 VDD.n1156 VSS 0.02556f
C1884 VDD.n1157 VSS 0.02556f
C1885 VDD.n1158 VSS 0.07151f
C1886 VDD.n1159 VSS 0.07151f
C1887 VDD.n1160 VSS 0.07151f
C1888 VDD.n1161 VSS 0.02556f
C1889 VDD.n1162 VSS 0.02556f
C1890 VDD.n1163 VSS 0.01917f
C1891 VDD.n1164 VSS 0.02556f
C1892 VDD.n1165 VSS 0.02556f
C1893 VDD.n1166 VSS 0.02556f
C1894 VDD.n1167 VSS 0.02556f
C1895 VDD.n1168 VSS 0.07149f
C1896 VDD.n1169 VSS 0.07183f
C1897 VDD.n1170 VSS 0.07561f
C1898 VDD.n1171 VSS 0.0269f
C1899 VDD.n1172 VSS 0.0269f
C1900 VDD.n1173 VSS 0.0269f
C1901 VDD.n1174 VSS 0.0269f
C1902 VDD.n1175 VSS 0.02556f
C1903 VDD.n1176 VSS 0.02556f
C1904 VDD.n1177 VSS 0.02556f
C1905 VDD.n1178 VSS 0.07186f
C1906 VDD.n1179 VSS 0.07186f
C1907 VDD.n1180 VSS 0.07186f
C1908 VDD.n1181 VSS 0.02556f
C1909 VDD.n1182 VSS 0.02556f
C1910 VDD.n1183 VSS 0.02556f
C1911 VDD.n1184 VSS 0.01917f
C1912 VDD.n1185 VSS 0.01278f
C1913 VDD.n1186 VSS 0.01917f
C1914 VDD.n1187 VSS 0.02556f
C1915 VDD.n1188 VSS 0.02556f
C1916 VDD.n1189 VSS 0.07037f
C1917 VDD.n1190 VSS 0.07491f
C1918 VDD.n1191 VSS 0.03593f
C1919 VDD.n1192 VSS 0.03743f
C1920 VDD.n1193 VSS 0.07186f
C1921 VDD.n1194 VSS 0.02556f
C1922 VDD.n1195 VSS 0.02556f
C1923 VDD.n1196 VSS 0.02556f
C1924 VDD.n1197 VSS 0.02556f
C1925 VDD.n1198 VSS 0.0269f
C1926 VDD.n1199 VSS 0.0269f
C1927 VDD.n1200 VSS 0.0269f
C1928 VDD.n1201 VSS 0.07561f
C1929 VDD.n1202 VSS 0.07561f
C1930 VDD.n1203 VSS 0.07186f
C1931 VDD.n1204 VSS 0.07186f
C1932 VDD.n1205 VSS 0.02556f
C1933 VDD.n1206 VSS 0.02556f
C1934 VDD.n1207 VSS 0.02556f
C1935 VDD.n1208 VSS 0.02556f
C1936 VDD.n1209 VSS 0.02556f
C1937 VDD.n1210 VSS 0.02556f
C1938 VDD.n1211 VSS 0.02556f
C1939 VDD.n1212 VSS 0.02556f
C1940 VDD.n1213 VSS 0.0718f
C1941 VDD.n1214 VSS 0.07148f
C1942 VDD.n1215 VSS 0.07151f
C1943 VDD.n1216 VSS 0.07151f
C1944 VDD.n1217 VSS 0.02556f
C1945 VDD.n1218 VSS 0.07151f
C1946 VDD.n1219 VSS 0.07523f
C1947 VDD.n1220 VSS 0.07523f
C1948 VDD.n1221 VSS 0.07151f
C1949 VDD.n1222 VSS 0.07151f
C1950 VDD.n1223 VSS 0.07151f
C1951 VDD.n1224 VSS 0.02556f
C1952 VDD.n1225 VSS 0.02556f
C1953 VDD.n1226 VSS 0.02556f
C1954 VDD.n1227 VSS 0.02556f
C1955 VDD.n1228 VSS 0.02556f
C1956 VDD.n1229 VSS 0.02556f
C1957 VDD.n1230 VSS 0.0269f
C1958 VDD.n1231 VSS 0.0269f
C1959 VDD.n1232 VSS 0.0269f
C1960 VDD.n1233 VSS 0.02556f
C1961 VDD.n1234 VSS 0.02556f
C1962 VDD.n1235 VSS 0.02556f
C1963 VDD.n1236 VSS 0.02556f
C1964 VDD.n1237 VSS 0.02556f
C1965 VDD.n1238 VSS 0.01917f
C1966 VDD.n1239 VSS 0.01278f
C1967 VDD.n1240 VSS 1.26621f
C1968 VDD.n1241 VSS 1.26621f
C1969 VDD.n1242 VSS 1.26621f
C1970 VDD.n1243 VSS 0.01278f
C1971 VDD.n1244 VSS 0.01917f
C1972 VDD.n1245 VSS 0.02556f
C1973 VDD.n1246 VSS 0.02556f
C1974 VDD.n1247 VSS 0.07151f
C1975 VDD.n1248 VSS 0.07151f
C1976 VDD.n1249 VSS 0.07151f
C1977 VDD.n1250 VSS 0.02556f
C1978 VDD.n1251 VSS 0.02556f
C1979 VDD.n1252 VSS 0.02556f
C1980 VDD.n1253 VSS 0.02556f
C1981 VDD.n1254 VSS 0.0269f
C1982 VDD.n1255 VSS 0.0269f
C1983 VDD.n1256 VSS 0.0269f
C1984 VDD.n1257 VSS 0.07523f
C1985 VDD.n1258 VSS 0.07523f
C1986 VDD.n1259 VSS 0.07151f
C1987 VDD.n1260 VSS 0.02556f
C1988 VDD.n1261 VSS 0.02556f
C1989 VDD.n1262 VSS 0.02556f
C1990 VDD.n1263 VSS 0.02556f
C1991 VDD.n1264 VSS 0.01917f
C1992 VDD.n1265 VSS 0.02556f
C1993 VDD.n1266 VSS 0.02556f
C1994 VDD.n1267 VSS 0.02556f
C1995 VDD.n1268 VSS 0.07151f
C1996 VDD.n1269 VSS 0.07151f
C1997 VDD.n1270 VSS 0.07151f
C1998 VDD.n1271 VSS 0.02556f
C1999 VDD.n1272 VSS 0.02556f
C2000 VDD.n1273 VSS 0.01917f
C2001 VDD.n1274 VSS 0.02556f
C2002 VDD.n1275 VSS 0.02556f
C2003 VDD.n1276 VSS 0.02556f
C2004 VDD.n1277 VSS 0.02556f
C2005 VDD.n1278 VSS 0.07151f
C2006 VDD.n1279 VSS 0.07151f
C2007 VDD.n1280 VSS 0.07523f
C2008 VDD.n1281 VSS 0.0269f
C2009 VDD.n1282 VSS 0.0269f
C2010 VDD.n1283 VSS 0.0269f
C2011 VDD.n1284 VSS 0.0269f
C2012 VDD.n1285 VSS 0.02556f
C2013 VDD.n1286 VSS 0.02556f
C2014 VDD.n1287 VSS 0.02556f
C2015 VDD.n1288 VSS 0.07151f
C2016 VDD.n1289 VSS 0.07151f
C2017 VDD.n1290 VSS 0.07151f
C2018 VDD.n1291 VSS 0.02556f
C2019 VDD.n1292 VSS 0.02556f
C2020 VDD.n1293 VSS 0.02556f
C2021 VDD.n1294 VSS 0.01917f
C2022 VDD.n1295 VSS 0.01278f
C2023 VDD.n1296 VSS 0.01917f
C2024 VDD.n1297 VSS 0.02556f
C2025 VDD.n1298 VSS 0.02556f
C2026 VDD.n1299 VSS 0.07151f
C2027 VDD.n1300 VSS 0.07151f
C2028 VDD.n1301 VSS 0.07151f
C2029 VDD.n1302 VSS 0.02556f
C2030 VDD.n1303 VSS 0.02556f
C2031 VDD.n1304 VSS 0.02556f
C2032 VDD.n1305 VSS 0.02556f
C2033 VDD.n1306 VSS 0.0269f
C2034 VDD.n1307 VSS 0.0269f
C2035 VDD.n1308 VSS 0.0269f
C2036 VDD.n1309 VSS 0.07523f
C2037 VDD.n1310 VSS 0.07523f
C2038 VDD.n1311 VSS 0.07151f
C2039 VDD.n1312 VSS 0.07151f
C2040 VDD.n1313 VSS 0.02556f
C2041 VDD.n1314 VSS 0.02556f
C2042 VDD.n1315 VSS 0.02556f
C2043 VDD.n1316 VSS 0.02556f
C2044 VDD.n1317 VSS 0.02556f
C2045 VDD.n1318 VSS 0.02556f
C2046 VDD.n1319 VSS 0.02556f
C2047 VDD.n1320 VSS 0.02556f
C2048 VDD.n1321 VSS 0.07151f
C2049 VDD.n1322 VSS 0.0715f
C2050 VDD.n1323 VSS 0.07186f
C2051 VDD.n1324 VSS 0.07186f
C2052 VDD.n1325 VSS 0.02556f
C2053 VDD.n1326 VSS 0.07186f
C2054 VDD.n1327 VSS 0.07561f
C2055 VDD.n1328 VSS 0.07561f
C2056 VDD.n1329 VSS 0.07186f
C2057 VDD.n1330 VSS 0.07186f
C2058 VDD.n1331 VSS 0.02556f
C2059 VDD.n1332 VSS 0.02556f
C2060 VDD.n1333 VSS 0.02556f
C2061 VDD.n1334 VSS 0.02556f
C2062 VDD.n1335 VSS 0.02556f
C2063 VDD.n1336 VSS 0.0269f
C2064 VDD.n1337 VSS 0.0269f
C2065 VDD.n1338 VSS 0.0269f
C2066 VDD.n1339 VSS 0.02556f
C2067 VDD.n1340 VSS 0.02556f
C2068 VDD.n1341 VSS 0.02556f
C2069 VDD.n1342 VSS 0.02556f
C2070 VDD.n1343 VSS 0.02556f
C2071 VDD.n1344 VSS 0.01917f
C2072 VDD.n1345 VSS 0.01278f
C2073 VDD.n1346 VSS 1.26621f
C2074 VDD.n1347 VSS 0.63767f
C2075 VDD.n1348 VSS 0.01917f
C2076 VDD.n1349 VSS 0.02556f
C2077 VDD.n1350 VSS 0.02556f
C2078 VDD.n1351 VSS 0.02556f
C2079 VDD.n1352 VSS 0.02556f
C2080 VDD.n1353 VSS 0.02556f
C2081 VDD.n1354 VSS 0.02556f
C2082 VDD.n1355 VSS 0.0269f
C2083 VDD.n1356 VSS 0.0269f
C2084 VDD.n1357 VSS 0.0269f
C2085 VDD.n1358 VSS 0.02556f
C2086 VDD.n1359 VSS 0.02556f
C2087 VDD.n1360 VSS 0.01917f
C2088 VDD.n1361 VSS 0.02556f
C2089 VDD.n1362 VSS 0.02556f
C2090 VDD.n1363 VSS 0.02556f
C2091 VDD.n1364 VSS 0.02556f
C2092 VDD.n1365 VSS 0.01278f
C2093 VDD.n1366 VSS 0.02556f
C2094 VDD.n1367 VSS 0.02556f
C2095 VDD.n1368 VSS 0.02556f
C2096 VDD.n1369 VSS 0.02556f
C2097 VDD.n1370 VSS 0.02556f
C2098 VDD.n1371 VSS 0.02556f
C2099 VDD.n1372 VSS 0.02556f
C2100 VDD.n1373 VSS 0.02556f
C2101 VDD.n1374 VSS 0.02556f
C2102 VDD.n1375 VSS 0.02556f
C2103 VDD.n1376 VSS 0.01917f
C2104 VDD.n1377 VSS 1.26621f
C2105 VDD.n1378 VSS 0.01917f
C2106 VDD.n1379 VSS 0.02556f
C2107 VDD.n1380 VSS 0.02556f
C2108 VDD.n1381 VSS 0.02556f
C2109 VDD.n1382 VSS 0.02556f
C2110 VDD.n1383 VSS 0.02556f
C2111 VDD.n1384 VSS 0.02556f
C2112 VDD.n1385 VSS 0.0269f
C2113 VDD.n1386 VSS 0.0269f
C2114 VDD.n1387 VSS 0.0269f
C2115 VDD.n1388 VSS 0.02556f
C2116 VDD.n1389 VSS 0.02556f
C2117 VDD.n1390 VSS 0.01917f
C2118 VDD.n1391 VSS 0.02556f
C2119 VDD.n1392 VSS 0.02556f
C2120 VDD.n1393 VSS 0.02556f
C2121 VDD.n1394 VSS 0.02556f
C2122 VDD.n1395 VSS 0.01278f
C2123 VDD.n1396 VSS 0.02556f
C2124 VDD.n1397 VSS 0.02556f
C2125 VDD.n1398 VSS 0.02556f
C2126 VDD.n1399 VSS 0.0269f
C2127 VDD.n1400 VSS 0.0269f
C2128 VDD.n1401 VSS 0.02556f
C2129 VDD.n1402 VSS 0.02556f
C2130 VDD.n1403 VSS 0.02556f
C2131 VDD.n1404 VSS 0.02556f
C2132 VDD.n1405 VSS 0.02556f
C2133 VDD.n1406 VSS 0.01917f
C2134 VDD.n1407 VSS 1.26621f
C2135 VDD.n1408 VSS 0.01917f
C2136 VDD.n1409 VSS 0.02556f
C2137 VDD.n1410 VSS 0.02556f
C2138 VDD.n1411 VSS 0.02556f
C2139 VDD.n1412 VSS 0.02556f
C2140 VDD.n1413 VSS 0.02556f
C2141 VDD.n1414 VSS 0.02556f
C2142 VDD.n1415 VSS 0.0269f
C2143 VDD.n1416 VSS 0.0269f
C2144 VDD.n1417 VSS 0.0269f
C2145 VDD.n1418 VSS 0.02556f
C2146 VDD.n1419 VSS 0.02556f
C2147 VDD.n1420 VSS 0.01917f
C2148 VDD.n1421 VSS 0.02556f
C2149 VDD.n1422 VSS 0.02556f
C2150 VDD.n1423 VSS 0.02556f
C2151 VDD.n1424 VSS 0.02556f
C2152 VDD.n1425 VSS 0.01278f
C2153 VDD.n1426 VSS 0.02556f
C2154 VDD.n1427 VSS 0.02556f
C2155 VDD.n1428 VSS 0.02556f
C2156 VDD.n1429 VSS 0.0269f
C2157 VDD.n1430 VSS 0.0269f
C2158 VDD.n1431 VSS 0.02556f
C2159 VDD.n1432 VSS 0.02556f
C2160 VDD.n1433 VSS 0.02556f
C2161 VDD.n1434 VSS 0.02556f
C2162 VDD.n1435 VSS 0.02556f
C2163 VDD.n1436 VSS 0.01917f
C2164 VDD.n1437 VSS 0.01917f
C2165 VDD.n1438 VSS 0.02556f
C2166 VDD.n1439 VSS 0.02556f
C2167 VDD.n1440 VSS 0.02556f
C2168 VDD.n1441 VSS 0.02556f
C2169 VDD.n1442 VSS 0.02556f
C2170 VDD.n1443 VSS 0.02556f
C2171 VDD.n1444 VSS 0.0269f
C2172 VDD.n1445 VSS 0.0269f
C2173 VDD.n1446 VSS 0.0269f
C2174 VDD.n1447 VSS 0.02556f
C2175 VDD.n1448 VSS 0.02556f
C2176 VDD.n1449 VSS 0.01917f
C2177 VDD.n1450 VSS 0.02556f
C2178 VDD.n1451 VSS 0.02556f
C2179 VDD.n1452 VSS 0.02556f
C2180 VDD.n1453 VSS 0.02556f
C2181 VDD.n1454 VSS 0.01278f
C2182 VDD.n1455 VSS 0.02556f
C2183 VDD.n1456 VSS 0.02556f
C2184 VDD.n1457 VSS 0.02556f
C2185 VDD.n1458 VSS 0.0269f
C2186 VDD.n1459 VSS 0.0269f
C2187 VDD.n1460 VSS 0.02556f
C2188 VDD.n1461 VSS 0.02556f
C2189 VDD.n1462 VSS 0.02556f
C2190 VDD.n1463 VSS 0.07151f
C2191 VDD.n1464 VSS 0.02556f
C2192 VDD.n1465 VSS 0.02556f
C2193 VDD.n1466 VSS 0.0269f
C2194 VDD.n1467 VSS 0.0269f
C2195 VDD.n1468 VSS 0.0269f
C2196 VDD.n1469 VSS 0.07151f
C2197 VDD.n1470 VSS 0.02556f
C2198 VDD.n1471 VSS 0.02556f
C2199 VDD.n1472 VSS 0.02556f
C2200 VDD.n1473 VSS 0.02556f
C2201 VDD.n1474 VSS 0.02556f
C2202 VDD.n1475 VSS 0.07151f
C2203 VDD.n1476 VSS 0.02556f
C2204 VDD.n1477 VSS 0.02556f
C2205 VDD.n1478 VSS 0.0269f
C2206 VDD.n1479 VSS 0.0269f
C2207 VDD.n1480 VSS 0.0269f
C2208 VDD.n1481 VSS 0.07151f
C2209 VDD.n1482 VSS 0.02556f
C2210 VDD.n1483 VSS 0.02556f
C2211 VDD.n1484 VSS 0.02556f
C2212 VDD.n1485 VSS 0.02556f
C2213 VDD.n1486 VSS 0.02556f
C2214 VDD.n1487 VSS 0.07151f
C2215 VDD.n1488 VSS 0.02556f
C2216 VDD.n1489 VSS 0.02556f
C2217 VDD.n1490 VSS 0.0269f
C2218 VDD.n1491 VSS 0.0269f
C2219 VDD.n1492 VSS 0.0269f
C2220 VDD.n1493 VSS 0.07151f
C2221 VDD.n1494 VSS 0.02556f
C2222 VDD.n1495 VSS 0.02556f
C2223 VDD.n1496 VSS 0.02556f
C2224 VDD.n1497 VSS 0.02556f
C2225 VDD.n1498 VSS 0.02556f
C2226 VDD.n1500 VSS 0.02556f
C2227 VDD.n1503 VSS 0.02556f
C2228 VDD.n1506 VSS 0.02556f
C2229 VDD.n1507 VSS 0.02556f
C2230 VDD.n1508 VSS 0.02556f
C2231 VDD.n1510 VSS 0.3282f
C2232 VDD.n1511 VSS 0.01096f
C2233 VDD.n1512 VSS 0.01096f
C2234 VDD.n1513 VSS 0.01096f
C2235 VDD.n1514 VSS 0.01096f
C2236 VDD.t40 VSS 0.1131f
C2237 VDD.n1515 VSS 0.03228f
C2238 VDD.t46 VSS 0.08864f
C2239 VDD.n1516 VSS 0.03065f
C2240 VDD.t52 VSS 0.08864f
C2241 VDD.n1517 VSS 0.0306f
C2242 VDD.n1518 VSS 0.02674f
C2243 VDD.t58 VSS 0.08864f
C2244 VDD.n1519 VSS 0.03054f
C2245 VDD.t64 VSS 0.08868f
C2246 VDD.n1520 VSS 0.03956f
C2247 VDD.t65 VSS 0.09911f
C2248 VDD.n1521 VSS 0.03956f
C2249 VDD.t67 VSS 0.09911f
C2250 VDD.n1522 VSS 0.03956f
C2251 VDD.t69 VSS 0.08868f
C2252 VDD.t63 VSS 0.08864f
C2253 VDD.t57 VSS 0.08864f
C2254 VDD.n1523 VSS 0.0306f
C2255 VDD.n1524 VSS 0.02249f
C2256 VDD.t55 VSS 0.09907f
C2257 VDD.t49 VSS 0.09907f
C2258 VDD.t43 VSS 0.12354f
C2259 VDD.t45 VSS 0.1131f
C2260 VDD.t51 VSS 0.08864f
C2261 VDD.n1525 VSS 0.03066f
C2262 VDD.n1526 VSS 0.03387f
C2263 VDD.t41 VSS 0.12354f
C2264 VDD.t59 VSS 0.09907f
C2265 VDD.n1527 VSS 0.03054f
C2266 VDD.n1528 VSS 0.02674f
C2267 VDD.t53 VSS 0.09907f
C2268 VDD.n1529 VSS 0.0306f
C2269 VDD.t47 VSS 0.09907f
C2270 VDD.n1530 VSS 0.03066f
C2271 VDD.n1531 VSS 0.03228f
C2272 VDD.n1532 VSS 0.02249f
C2273 VDD.n1533 VSS 0.03128f
C2274 VDD.n1534 VSS 0.03228f
C2275 VDD.n1535 VSS 0.03066f
C2276 VDD.n1536 VSS 0.0306f
C2277 VDD.t61 VSS 0.09907f
C2278 VDD.n1537 VSS 0.03054f
C2279 VDD.n1538 VSS 0.02674f
C2280 VDD.n1539 VSS 0.03128f
C2281 VDD.n1540 VSS 0.02833f
C2282 VDD.n1541 VSS 0.03054f
C2283 VDD.n1542 VSS 0.04249f
C2284 VDD.n1543 VSS 0.06235f
C2285 VDD.n1544 VSS 0.0387f
C2286 VDD.n1545 VSS 0.02716f
C2287 VDD.t37 VSS 0.09911f
C2288 VDD.n1546 VSS 0.03956f
C2289 VDD.t35 VSS 0.09911f
C2290 VDD.n1547 VSS 0.03956f
C2291 VDD.t14 VSS 0.08864f
C2292 VDD.n1548 VSS 0.0306f
C2293 VDD.n1549 VSS 0.02249f
C2294 VDD.t15 VSS 0.09907f
C2295 VDD.t9 VSS 0.09907f
C2296 VDD.t3 VSS 0.12354f
C2297 VDD.t5 VSS 0.12354f
C2298 VDD.t23 VSS 0.09907f
C2299 VDD.n1550 VSS 0.03054f
C2300 VDD.n1551 VSS 0.02674f
C2301 VDD.t17 VSS 0.09907f
C2302 VDD.n1552 VSS 0.0306f
C2303 VDD.t11 VSS 0.09907f
C2304 VDD.n1553 VSS 0.03066f
C2305 VDD.n1554 VSS 0.03228f
C2306 VDD.n1555 VSS 0.02249f
C2307 VDD.t2 VSS 0.1131f
C2308 VDD.t8 VSS 0.08864f
C2309 VDD.n1556 VSS 0.03065f
C2310 VDD.n1557 VSS 0.03387f
C2311 VDD.n1558 VSS 0.03128f
C2312 VDD.n1559 VSS 0.03228f
C2313 VDD.n1560 VSS 0.03066f
C2314 VDD.n1561 VSS 0.0306f
C2315 VDD.t21 VSS 0.09907f
C2316 VDD.n1562 VSS 0.03054f
C2317 VDD.n1563 VSS 0.02674f
C2318 VDD.n1564 VSS 0.03128f
C2319 VDD.n1565 VSS 0.02833f
C2320 VDD.t20 VSS 0.08864f
C2321 VDD.n1566 VSS 0.03054f
C2322 VDD.t26 VSS 0.08868f
C2323 VDD.n1567 VSS 0.04249f
C2324 VDD.n1568 VSS 0.06235f
C2325 VDD.n1569 VSS 0.0387f
C2326 VDD.t39 VSS 0.08868f
C2327 VDD.t25 VSS 0.08864f
C2328 VDD.t19 VSS 0.08864f
C2329 VDD.t13 VSS 0.08864f
C2330 VDD.t7 VSS 0.1131f
C2331 VDD.n1570 VSS 0.03228f
C2332 VDD.n1571 VSS 0.03066f
C2333 VDD.n1572 VSS 0.0306f
C2334 VDD.n1573 VSS 0.02674f
C2335 VDD.n1574 VSS 0.03054f
C2336 VDD.n1575 VSS 0.03956f
C2337 VDD.n1576 VSS 0.02716f
C2338 VDD.n1577 VSS 1.6915f
C2339 VDD.n1578 VSS 2.12503f
C2340 VDD.n1579 VSS 5.59783f
C2341 VDD.n1580 VSS 2.36944f
C2342 VDD.n1581 VSS 0.07149f
C2343 VDD.n1582 VSS 0.02556f
C2344 VDD.n1583 VSS 0.02556f
C2345 VDD.n1584 VSS 0.0269f
C2346 VDD.n1585 VSS 0.0269f
C2347 VDD.n1586 VSS 0.0269f
C2348 VDD.n1587 VSS 0.07186f
C2349 VDD.n1588 VSS 0.02556f
C2350 VDD.n1589 VSS 0.02556f
C2351 VDD.n1590 VSS 0.02556f
C2352 VDD.n1591 VSS 0.02556f
C2353 VDD.n1592 VSS 0.02556f
C2354 VDD.n1593 VSS 0.07186f
C2355 VDD.n1594 VSS 0.07186f
C2356 VDD.n1595 VSS 0.02556f
C2357 VDD.n1596 VSS 0.02556f
C2358 VDD.n1597 VSS 0.02556f
C2359 VDD.n1598 VSS 0.02556f
C2360 VDD.n1599 VSS 0.0269f
C2361 VDD.n1600 VSS 0.0269f
C2362 VDD.n1601 VSS 0.0269f
C2363 VDD.n1602 VSS 0.07561f
C2364 VDD.n1603 VSS 0.07561f
C2365 VDD.n1604 VSS 0.07176f
C2366 VDD.n1605 VSS 0.07186f
C2367 VDD.n1606 VSS 0.02556f
C2368 VDD.n1607 VSS 0.02556f
C2369 VDD.n1608 VSS 0.02556f
C2370 VDD.n1609 VSS 0.02556f
C2371 VDD.n1610 VSS 0.02556f
C2372 VDD.n1611 VSS 0.02556f
C2373 VDD.n1612 VSS 0.02556f
C2374 VDD.n1613 VSS 0.02556f
C2375 VDD.n1614 VSS 0.07151f
C2376 VDD.n1615 VSS 0.07151f
C2377 VDD.n1616 VSS 0.07151f
C2378 VDD.n1617 VSS 0.07151f
C2379 VDD.n1618 VSS 0.02556f
C2380 VDD.n1619 VSS 0.07151f
C2381 VDD.n1620 VSS 0.07523f
C2382 VDD.n1621 VSS 0.07523f
C2383 VDD.n1622 VSS 0.07151f
C2384 VDD.n1623 VSS 0.02556f
C2385 VDD.n1624 VSS 0.07113f
C2386 VDD.n1625 VSS 1.36845f
C2387 VDD.n1626 VSS 0.07113f
C2388 VDD.n1627 VSS 0.02556f
C2389 VDD.n1628 VSS 0.02556f
C2390 VDD.n1629 VSS 0.02556f
C2391 VDD.n1630 VSS 0.02556f
C2392 VDD.n1631 VSS 0.0269f
C2393 VDD.n1632 VSS 0.0269f
C2394 VDD.n1633 VSS 0.0269f
C2395 VDD.n1634 VSS 0.07523f
C2396 VDD.n1635 VSS 0.07523f
C2397 VDD.n1636 VSS 0.07151f
C2398 VDD.n1637 VSS 0.07151f
C2399 VDD.n1638 VSS 0.02556f
C2400 VDD.n1639 VSS 0.02556f
C2401 VDD.n1640 VSS 0.02556f
C2402 VDD.n1641 VSS 0.02556f
C2403 VDD.n1642 VSS 0.02556f
C2404 VDD.n1643 VSS 0.02556f
C2405 VDD.n1644 VSS 0.02556f
C2406 VDD.n1645 VSS 0.02556f
C2407 VDD.n1646 VSS 0.07151f
C2408 VDD.n1647 VSS 0.07151f
C2409 VDD.n1648 VSS 0.07149f
C2410 VDD.n1649 VSS 0.07176f
C2411 VDD.n1650 VSS 0.02556f
C2412 VDD.n1651 VSS 0.07186f
C2413 VDD.n1652 VSS 0.07561f
C2414 VDD.n1653 VSS 0.07561f
C2415 VDD.n1654 VSS 0.07186f
C2416 VDD.n1655 VSS 0.02556f
C2417 VDD.n1656 VSS 0.07186f
C2418 VDD.n1657 VSS 0.07186f
C2419 VDD.n1658 VSS 0.07186f
C2420 VDD.n1659 VSS 0.04192f
C2421 VDD.n1660 VSS 0.06135f
C2422 VDD.n1661 VSS 0.03593f
C2423 VDD.n1662 VSS 0.02556f
C2424 VDD.n1663 VSS 0.06588f
C2425 VDD.n1664 VSS 0.07186f
C2426 VDD.n1665 VSS 0.07186f
C2427 VDD.n1666 VSS 0.07561f
C2428 VDD.n1667 VSS 0.0269f
C2429 VDD.n1668 VSS 0.07561f
C2430 VDD.n1669 VSS 0.07186f
C2431 VDD.n1670 VSS 0.07186f
C2432 VDD.n1671 VSS 0.07186f
C2433 VDD.n1672 VSS 0.0715f
C2434 VDD.n1673 VSS 0.02556f
C2435 VDD.n1674 VSS 0.02556f
C2436 VDD.n1675 VSS 0.02556f
C2437 VDD.n1676 VSS 0.07151f
C2438 VDD.n1677 VSS 0.07151f
C2439 VDD.n1678 VSS 0.07151f
C2440 VDD.n1679 VSS 0.02556f
C2441 VDD.n1680 VSS 0.02556f
C2442 VDD.n1681 VSS 0.02556f
C2443 VDD.n1682 VSS 0.02556f
C2444 VDD.n1683 VSS 0.0269f
C2445 VDD.n1684 VSS 0.0269f
C2446 VDD.n1685 VSS 0.0269f
C2447 VDD.n1686 VSS 0.07523f
C2448 VDD.n1687 VSS 0.07523f
C2449 VDD.n1688 VSS 0.07151f
C2450 VDD.n1689 VSS 0.07151f
C2451 VDD.n1690 VSS 0.02556f
C2452 VDD.n1691 VSS 0.02556f
C2453 VDD.n1692 VSS 0.02556f
C2454 VDD.n1693 VSS 0.02556f
C2455 VDD.n1694 VSS 0.02556f
C2456 VDD.n1695 VSS 0.02556f
C2457 VDD.n1696 VSS 0.02556f
C2458 VDD.n1697 VSS 0.02556f
C2459 VDD.n1698 VSS 0.07151f
C2460 VDD.n1699 VSS 0.07151f
C2461 VDD.n1700 VSS 0.07151f
C2462 VDD.n1701 VSS 0.07151f
C2463 VDD.n1702 VSS 0.02556f
C2464 VDD.n1703 VSS 0.07151f
C2465 VDD.n1704 VSS 0.07523f
C2466 VDD.n1705 VSS 0.07523f
C2467 VDD.n1706 VSS 0.07151f
C2468 VDD.n1707 VSS 0.02556f
C2469 VDD.n1708 VSS 0.07151f
C2470 VDD.n1709 VSS 0.07151f
C2471 VDD.n1710 VSS 0.07151f
C2472 VDD.n1711 VSS 0.07151f
C2473 VDD.n1712 VSS 0.02556f
C2474 VDD.n1713 VSS 0.07151f
C2475 VDD.n1714 VSS 0.07151f
C2476 VDD.n1715 VSS 0.07151f
C2477 VDD.n1716 VSS 0.07523f
C2478 VDD.n1717 VSS 0.0269f
C2479 VDD.n1718 VSS 0.07523f
C2480 VDD.n1719 VSS 0.07151f
C2481 VDD.n1720 VSS 0.07151f
C2482 VDD.n1721 VSS 0.07151f
C2483 VDD.n1722 VSS 0.07151f
C2484 VDD.n1723 VSS 0.02556f
C2485 VDD.n1724 VSS 0.02556f
C2486 VDD.n1725 VSS 0.02556f
C2487 VDD.n1726 VSS 0.07151f
C2488 VDD.n1727 VSS 0.07151f
C2489 VDD.n1728 VSS 0.07151f
C2490 VDD.n1729 VSS 0.02556f
C2491 VDD.n1730 VSS 0.02556f
C2492 VDD.n1731 VSS 0.02556f
C2493 VDD.n1732 VSS 0.02556f
C2494 VDD.n1733 VSS 0.0269f
C2495 VDD.n1734 VSS 0.0269f
C2496 VDD.n1735 VSS 0.0269f
C2497 VDD.n1736 VSS 0.07523f
C2498 VDD.n1737 VSS 0.07523f
C2499 VDD.n1738 VSS 0.07151f
C2500 VDD.n1739 VSS 0.07151f
C2501 VDD.n1740 VSS 0.02556f
C2502 VDD.n1741 VSS 0.02556f
C2503 VDD.n1742 VSS 0.02556f
C2504 VDD.n1743 VSS 0.02556f
C2505 VDD.n1744 VSS 0.02556f
C2506 VDD.n1745 VSS 0.02556f
C2507 VDD.n1746 VSS 0.02556f
C2508 VDD.n1747 VSS 0.02556f
C2509 VDD.n1748 VSS 0.07148f
C2510 VDD.n1749 VSS 0.0718f
C2511 VDD.n1750 VSS 0.07186f
C2512 VDD.n1751 VSS 0.07186f
C2513 VDD.n1752 VSS 0.02556f
C2514 VDD.n1753 VSS 0.07186f
C2515 VDD.n1754 VSS 0.07561f
C2516 VDD.n1755 VSS 0.07561f
C2517 VDD.n1756 VSS 0.07186f
C2518 VDD.n1757 VSS 0.02556f
C2519 VDD.n1758 VSS 0.07186f
C2520 VDD.n1759 VSS 0.03743f
C2521 VDD.n1760 VSS 0.07404f
C2522 VDD.n1761 VSS 0.03593f
C2523 VDD.n1762 VSS 0.07037f
C2524 VDD.n1763 VSS 0.07186f
C2525 VDD.n1764 VSS 0.02556f
C2526 VDD.n1765 VSS 0.07186f
C2527 VDD.n1766 VSS 0.07186f
C2528 VDD.n1767 VSS 0.07186f
C2529 VDD.n1768 VSS 0.07561f
C2530 VDD.n1769 VSS 0.0269f
C2531 VDD.n1770 VSS 0.07561f
C2532 VDD.n1771 VSS 0.07183f
C2533 VDD.n1772 VSS 0.07149f
C2534 VDD.n1773 VSS 0.07151f
C2535 VDD.n1774 VSS 0.07151f
C2536 VDD.n1775 VSS 0.07151f
C2537 VDD.n1776 VSS 0.07151f
C2538 VDD.n1777 VSS 0.07151f
C2539 VDD.n1778 VSS 0.02556f
C2540 VDD.n1779 VSS 0.02556f
C2541 VDD.n1780 VSS 0.02556f
C2542 VDD.n1781 VSS 0.02556f
C2543 VDD.n1782 VSS 0.02556f
C2544 VDD.n1783 VSS 0.02556f
C2545 VDD.n1784 VSS 0.02556f
C2546 VDD.n1785 VSS 0.0269f
C2547 VDD.n1786 VSS 0.0269f
C2548 VDD.n1787 VSS 0.0269f
C2549 VDD.n1788 VSS 0.02556f
C2550 VDD.n1789 VSS 0.02556f
C2551 VDD.n1790 VSS 0.02556f
C2552 VDD.n1791 VSS 0.02556f
C2553 VDD.n1792 VSS 0.01917f
C2554 VDD.n1793 VSS 0.02556f
C2555 VDD.n1794 VSS 0.02556f
C2556 VDD.n1795 VSS 0.02556f
C2557 VDD.n1796 VSS 0.02556f
C2558 VDD.n1797 VSS 0.02556f
C2559 VDD.n1798 VSS 0.02556f
C2560 VDD.n1799 VSS 0.02556f
C2561 VDD.n1800 VSS 0.0269f
C2562 VDD.n1801 VSS 0.0269f
C2563 VDD.n1802 VSS 0.0269f
C2564 VDD.n1803 VSS 0.02556f
C2565 VDD.n1804 VSS 0.02556f
C2566 VDD.n1805 VSS 0.02556f
C2567 VDD.n1806 VSS 0.02556f
C2568 VDD.n1807 VSS 0.02556f
C2569 VDD.n1808 VSS 0.01917f
C2570 VDD.n1809 VSS 0.01278f
C2571 VDD.n1810 VSS 1.26621f
C2572 VDD.n1811 VSS 1.26621f
C2573 VDD.n1812 VSS 0.01278f
C2574 VDD.n1813 VSS 0.01917f
C2575 VDD.n1814 VSS 0.02556f
C2576 VDD.n1815 VSS 0.02556f
C2577 VDD.n1816 VSS 0.02556f
C2578 VDD.n1817 VSS 0.02556f
C2579 VDD.n1818 VSS 0.02556f
C2580 VDD.n1819 VSS 0.0269f
C2581 VDD.n1820 VSS 0.0269f
C2582 VDD.n1821 VSS 0.0269f
C2583 VDD.n1822 VSS 0.02556f
C2584 VDD.n1823 VSS 0.02556f
C2585 VDD.n1824 VSS 0.02556f
C2586 VDD.n1825 VSS 0.02556f
C2587 VDD.n1826 VSS 0.01917f
C2588 VDD.n1827 VSS 0.02556f
C2589 VDD.n1828 VSS 0.02556f
C2590 VDD.n1829 VSS 0.02556f
C2591 VDD.n1830 VSS 0.02556f
C2592 VDD.n1831 VSS 0.02556f
C2593 VDD.n1832 VSS 0.02556f
C2594 VDD.n1833 VSS 0.02556f
C2595 VDD.n1834 VSS 0.0269f
C2596 VDD.n1835 VSS 0.0269f
C2597 VDD.n1836 VSS 0.0269f
C2598 VDD.n1837 VSS 0.02556f
C2599 VDD.n1838 VSS 0.02556f
C2600 VDD.n1839 VSS 0.02556f
C2601 VDD.n1840 VSS 0.02556f
C2602 VDD.n1841 VSS 0.02556f
C2603 VDD.n1842 VSS 0.01917f
C2604 VDD.n1843 VSS 0.01278f
C2605 VDD.n1844 VSS 1.26621f
C2606 VDD.n1845 VSS 1.26621f
C2607 VDD.n1846 VSS 0.01278f
C2608 VDD.n1847 VSS 0.01917f
C2609 VDD.n1848 VSS 0.02556f
C2610 VDD.n1849 VSS 0.02556f
C2611 VDD.n1850 VSS 0.02556f
C2612 VDD.n1851 VSS 0.02556f
C2613 VDD.n1852 VSS 0.02556f
C2614 VDD.n1853 VSS 0.0269f
C2615 VDD.n1854 VSS 0.0269f
C2616 VDD.n1855 VSS 0.0269f
C2617 VDD.n1856 VSS 0.02556f
C2618 VDD.n1857 VSS 0.02556f
C2619 VDD.n1858 VSS 0.02556f
C2620 VDD.n1859 VSS 0.02556f
C2621 VDD.n1860 VSS 0.01917f
C2622 VDD.n1861 VSS 0.02556f
C2623 VDD.n1862 VSS 0.02556f
C2624 VDD.n1863 VSS 0.02556f
C2625 VDD.n1864 VSS 0.02556f
C2626 VDD.n1865 VSS 0.02556f
C2627 VDD.n1866 VSS 0.02556f
C2628 VDD.n1867 VSS 0.02556f
C2629 VDD.n1868 VSS 0.0269f
C2630 VDD.n1869 VSS 0.0269f
C2631 VDD.n1870 VSS 0.0269f
C2632 VDD.n1871 VSS 0.02556f
C2633 VDD.n1872 VSS 0.02556f
C2634 VDD.n1873 VSS 0.02556f
C2635 VDD.n1874 VSS 0.02556f
C2636 VDD.n1875 VSS 0.02556f
C2637 VDD.n1876 VSS 0.01917f
C2638 VDD.n1877 VSS 0.01278f
C2639 VDD.n1878 VSS 1.26621f
C2640 VDD.n1879 VSS 0.9464f
C2641 VDD.n1880 VSS 0.01278f
C2642 VDD.n1881 VSS 0.01917f
C2643 VDD.n1882 VSS 0.02556f
C2644 VDD.n1883 VSS 0.02556f
C2645 VDD.n1884 VSS 0.02556f
C2646 VDD.n1885 VSS 0.02556f
C2647 VDD.n1886 VSS 0.02556f
C2648 VDD.n1887 VSS 0.02556f
C2649 VDD.n1888 VSS 0.02556f
C2650 VDD.n1889 VSS 0.02556f
C2651 VDD.n1890 VSS 0.02556f
C2652 VDD.n1891 VSS 0.02556f
C2653 VDD.n1892 VSS 0.02556f
C2654 VDD.n1893 VSS 0.02556f
C2655 VDD.n1894 VSS 0.01917f
C2656 VDD.n1895 VSS 0.02556f
C2657 VDD.n1896 VSS 0.02556f
C2658 VDD.n1897 VSS 0.02556f
C2659 VDD.n1898 VSS 0.02556f
C2660 VDD.n1899 VSS 0.02556f
C2661 VDD.n1900 VSS 0.02556f
C2662 VDD.n1901 VSS 0.02556f
C2663 VDD.n1902 VSS 0.0269f
C2664 VDD.n1903 VSS 0.0269f
C2665 VDD.n1904 VSS 0.0269f
C2666 VDD.n1905 VSS 0.02556f
C2667 VDD.n1906 VSS 0.02556f
C2668 VDD.n1907 VSS 0.02556f
C2669 VDD.n1908 VSS 0.02556f
C2670 VDD.n1909 VSS 0.02556f
C2671 VDD.n1910 VSS 0.01917f
C2672 VDD.n1911 VSS 0.01278f
C2673 VDD.n1912 VSS 1.26621f
C2674 VDD.n1913 VSS 1.26621f
C2675 VDD.n1914 VSS 0.01278f
C2676 VDD.n1915 VSS 0.01917f
C2677 VDD.n1916 VSS 0.02556f
C2678 VDD.n1917 VSS 0.02556f
C2679 VDD.n1918 VSS 0.04192f
C2680 VDD.n1919 VSS 0.03593f
C2681 VDD.n1920 VSS 0.0656f
C2682 VDD.n1921 VSS 1.64311f
C2683 VDD.n1922 VSS 0.02155f
C2684 VDD.n1923 VSS 3.67966f
C2685 VDD.n1926 VSS 0.02735f
C2686 VDD.t27 VSS 0.01773f
C2687 VDD.t31 VSS 0.01961f
C2688 VDD.n1927 VSS 0.01395f
C2689 VDD.t32 VSS 0.0217f
C2690 VDD.t28 VSS 0.01981f
C2691 VDD.n1928 VSS 0.01396f
C2692 VDD.t30 VSS 0.01773f
C2693 VDD.t34 VSS 0.01961f
C2694 VDD.n1929 VSS 0.01395f
C2695 VDD.t345 VSS 0.03529f
C2696 VDD.n1930 VSS 0.05427f
C2697 VDD.n1931 VSS 0.02492f
C2698 VDD.n1932 VSS 0.0333f
C2699 VDD.n1933 VSS 0.04602f
C2700 VDD.n1934 VSS 0.01734f
C2701 VDD.n1935 VSS 0.32671f
C2702 VDD.n1936 VSS 0.00514f
C2703 VDD.t335 VSS 0.01736f
C2704 VDD.n1937 VSS 0.00983f
C2705 VDD.t336 VSS 0.0194f
C2706 VDD.n1938 VSS 0.00983f
C2707 VDD.t338 VSS 0.0194f
C2708 VDD.n1939 VSS 0.00983f
C2709 VDD.t340 VSS 0.0194f
C2710 VDD.n1940 VSS 0.00983f
C2711 VDD.t342 VSS 0.0194f
C2712 VDD.n1941 VSS 0.00983f
C2713 VDD.t334 VSS 0.01735f
C2714 VDD.t324 VSS 0.01735f
C2715 VDD.n1942 VSS 0.00647f
C2716 VDD.n1943 VSS 0.01152f
C2717 VDD.t322 VSS 0.01939f
C2718 VDD.t312 VSS 0.01939f
C2719 VDD.t302 VSS 0.01939f
C2720 VDD.n1944 VSS 0.00647f
C2721 VDD.t314 VSS 0.01735f
C2722 VDD.n1945 VSS 0.00663f
C2723 VDD.n1946 VSS 0.00835f
C2724 VDD.n1947 VSS 0.01152f
C2725 VDD.t300 VSS 0.01939f
C2726 VDD.t290 VSS 0.01939f
C2727 VDD.t280 VSS 0.01939f
C2728 VDD.n1948 VSS 0.00646f
C2729 VDD.n1949 VSS 0.01558f
C2730 VDD.n1950 VSS 0.01152f
C2731 VDD.t278 VSS 0.01939f
C2732 VDD.n1951 VSS 0.00647f
C2733 VDD.t328 VSS 0.01939f
C2734 VDD.n1952 VSS 0.00633f
C2735 VDD.t316 VSS 0.01939f
C2736 VDD.t306 VSS 0.01939f
C2737 VDD.t296 VSS 0.01939f
C2738 VDD.n1953 VSS 0.00646f
C2739 VDD.t275 VSS 0.01735f
C2740 VDD.n1954 VSS 0.00646f
C2741 VDD.n1955 VSS 0.00514f
C2742 VDD.n1956 VSS 0.00514f
C2743 VDD.n1957 VSS 0.00514f
C2744 VDD.n1958 VSS 0.00514f
C2745 VDD.n1959 VSS 0.01152f
C2746 VDD.t95 VSS 0.01791f
C2747 VDD.n1960 VSS 0.01308f
C2748 VDD.t105 VSS 0.01735f
C2749 VDD.n1961 VSS 0.00662f
C2750 VDD.t115 VSS 0.01735f
C2751 VDD.n1962 VSS 0.00646f
C2752 VDD.n1963 VSS 0.00781f
C2753 VDD.t125 VSS 0.01735f
C2754 VDD.n1964 VSS 0.00662f
C2755 VDD.t135 VSS 0.01735f
C2756 VDD.n1965 VSS 0.00646f
C2757 VDD.n1966 VSS 0.00781f
C2758 VDD.t145 VSS 0.01735f
C2759 VDD.n1967 VSS 0.00662f
C2760 VDD.t155 VSS 0.01735f
C2761 VDD.n1968 VSS 0.00646f
C2762 VDD.n1969 VSS 0.01152f
C2763 VDD.t156 VSS 0.01939f
C2764 VDD.n1970 VSS 0.00646f
C2765 VDD.t206 VSS 0.01939f
C2766 VDD.n1971 VSS 0.00663f
C2767 VDD.n1972 VSS 0.01152f
C2768 VDD.t198 VSS 0.01939f
C2769 VDD.n1973 VSS 0.00647f
C2770 VDD.t228 VSS 0.01939f
C2771 VDD.n1974 VSS 0.00663f
C2772 VDD.n1975 VSS 0.01152f
C2773 VDD.t216 VSS 0.01939f
C2774 VDD.n1976 VSS 0.00646f
C2775 VDD.t246 VSS 0.01939f
C2776 VDD.n1977 VSS 0.00663f
C2777 VDD.n1978 VSS 0.01152f
C2778 VDD.t238 VSS 0.01939f
C2779 VDD.n1979 VSS 0.00647f
C2780 VDD.t268 VSS 0.01939f
C2781 VDD.n1980 VSS 0.00663f
C2782 VDD.n1981 VSS 0.01558f
C2783 VDD.t260 VSS 0.01939f
C2784 VDD.t250 VSS 0.01939f
C2785 VDD.t240 VSS 0.01939f
C2786 VDD.t230 VSS 0.01939f
C2787 VDD.t220 VSS 0.01939f
C2788 VDD.t210 VSS 0.01939f
C2789 VDD.t200 VSS 0.01939f
C2790 VDD.t190 VSS 0.01939f
C2791 VDD.t180 VSS 0.01939f
C2792 VDD.n1982 VSS 0.00646f
C2793 VDD.n1983 VSS 0.01558f
C2794 VDD.t178 VSS 0.01939f
C2795 VDD.t168 VSS 0.01939f
C2796 VDD.t158 VSS 0.01939f
C2797 VDD.t148 VSS 0.01939f
C2798 VDD.t138 VSS 0.01939f
C2799 VDD.n1984 VSS 0.00647f
C2800 VDD.n1985 VSS 0.01152f
C2801 VDD.t136 VSS 0.01939f
C2802 VDD.t126 VSS 0.01939f
C2803 VDD.t116 VSS 0.01939f
C2804 VDD.n1986 VSS 0.00647f
C2805 VDD.n1987 VSS 0.01152f
C2806 VDD.t118 VSS 0.01939f
C2807 VDD.t108 VSS 0.01939f
C2808 VDD.t98 VSS 0.01996f
C2809 VDD.n1988 VSS 0.01558f
C2810 VDD.t100 VSS 0.01996f
C2811 VDD.t170 VSS 0.01939f
C2812 VDD.n1989 VSS 0.00663f
C2813 VDD.n1990 VSS 0.00835f
C2814 VDD.t162 VSS 0.01939f
C2815 VDD.t152 VSS 0.01939f
C2816 VDD.t142 VSS 0.01939f
C2817 VDD.n1991 VSS 0.00647f
C2818 VDD.t144 VSS 0.01735f
C2819 VDD.t134 VSS 0.01735f
C2820 VDD.t124 VSS 0.01735f
C2821 VDD.t114 VSS 0.01735f
C2822 VDD.t104 VSS 0.01791f
C2823 VDD.n1992 VSS 0.01362f
C2824 VDD.n1993 VSS 0.00663f
C2825 VDD.n1994 VSS 0.00647f
C2826 VDD.t122 VSS 0.01939f
C2827 VDD.t112 VSS 0.01939f
C2828 VDD.t102 VSS 0.01996f
C2829 VDD.n1995 VSS 0.01308f
C2830 VDD.n1996 VSS 0.00663f
C2831 VDD.n1997 VSS 0.00647f
C2832 VDD.t132 VSS 0.01939f
C2833 VDD.n1998 VSS 0.00663f
C2834 VDD.n1999 VSS 0.00781f
C2835 VDD.n2000 VSS 0.01558f
C2836 VDD.n2001 VSS 0.00835f
C2837 VDD.n2002 VSS 0.00663f
C2838 VDD.n2003 VSS 0.00647f
C2839 VDD.t164 VSS 0.01735f
C2840 VDD.n2004 VSS 0.00647f
C2841 VDD.t154 VSS 0.01735f
C2842 VDD.n2005 VSS 0.00663f
C2843 VDD.n2006 VSS 0.00835f
C2844 VDD.n2007 VSS 0.01558f
C2845 VDD.n2008 VSS 0.00781f
C2846 VDD.n2009 VSS 0.00663f
C2847 VDD.n2010 VSS 0.00647f
C2848 VDD.t212 VSS 0.01939f
C2849 VDD.n2011 VSS 0.00663f
C2850 VDD.t204 VSS 0.01735f
C2851 VDD.t194 VSS 0.01735f
C2852 VDD.t184 VSS 0.01735f
C2853 VDD.t174 VSS 0.01735f
C2854 VDD.n2012 VSS 0.00663f
C2855 VDD.n2013 VSS 0.00647f
C2856 VDD.n2014 VSS 0.00835f
C2857 VDD.n2015 VSS 0.00663f
C2858 VDD.n2016 VSS 0.00647f
C2859 VDD.t234 VSS 0.01735f
C2860 VDD.n2017 VSS 0.00663f
C2861 VDD.t222 VSS 0.01939f
C2862 VDD.n2018 VSS 0.00647f
C2863 VDD.t292 VSS 0.01939f
C2864 VDD.n2019 VSS 0.00663f
C2865 VDD.n2020 VSS 0.00781f
C2866 VDD.t282 VSS 0.01939f
C2867 VDD.n2021 VSS 0.00647f
C2868 VDD.t272 VSS 0.01939f
C2869 VDD.n2022 VSS 0.00663f
C2870 VDD.n2023 VSS 0.00781f
C2871 VDD.t262 VSS 0.01939f
C2872 VDD.n2024 VSS 0.00647f
C2873 VDD.t252 VSS 0.01939f
C2874 VDD.n2025 VSS 0.00663f
C2875 VDD.t244 VSS 0.01735f
C2876 VDD.n2026 VSS 0.00647f
C2877 VDD.t304 VSS 0.01735f
C2878 VDD.n2027 VSS 0.00647f
C2879 VDD.t294 VSS 0.01735f
C2880 VDD.n2028 VSS 0.00663f
C2881 VDD.n2029 VSS 0.00835f
C2882 VDD.t284 VSS 0.01735f
C2883 VDD.n2030 VSS 0.00647f
C2884 VDD.t274 VSS 0.01735f
C2885 VDD.n2031 VSS 0.00663f
C2886 VDD.n2032 VSS 0.00835f
C2887 VDD.t264 VSS 0.01735f
C2888 VDD.n2033 VSS 0.00647f
C2889 VDD.t254 VSS 0.01735f
C2890 VDD.n2034 VSS 0.00663f
C2891 VDD.n2035 VSS 0.00835f
C2892 VDD.n2036 VSS 0.01558f
C2893 VDD.n2037 VSS 0.00781f
C2894 VDD.t242 VSS 0.01939f
C2895 VDD.n2038 VSS 0.00647f
C2896 VDD.t232 VSS 0.01939f
C2897 VDD.n2039 VSS 0.00663f
C2898 VDD.n2040 VSS 0.00781f
C2899 VDD.n2041 VSS 0.01558f
C2900 VDD.n2042 VSS 0.00835f
C2901 VDD.t224 VSS 0.01735f
C2902 VDD.n2043 VSS 0.00647f
C2903 VDD.t214 VSS 0.01735f
C2904 VDD.n2044 VSS 0.00663f
C2905 VDD.n2045 VSS 0.00835f
C2906 VDD.n2046 VSS 0.01558f
C2907 VDD.n2047 VSS 0.00781f
C2908 VDD.t202 VSS 0.01939f
C2909 VDD.n2048 VSS 0.00647f
C2910 VDD.t192 VSS 0.01939f
C2911 VDD.n2049 VSS 0.00663f
C2912 VDD.n2050 VSS 0.00781f
C2913 VDD.t182 VSS 0.01939f
C2914 VDD.n2051 VSS 0.00647f
C2915 VDD.t172 VSS 0.01939f
C2916 VDD.n2052 VSS 0.00663f
C2917 VDD.n2053 VSS 0.00781f
C2918 VDD.n2054 VSS 0.01558f
C2919 VDD.n2055 VSS 0.01152f
C2920 VDD.n2056 VSS 0.00781f
C2921 VDD.t160 VSS 0.01939f
C2922 VDD.n2057 VSS 0.00646f
C2923 VDD.t150 VSS 0.01939f
C2924 VDD.n2058 VSS 0.00663f
C2925 VDD.n2059 VSS 0.00781f
C2926 VDD.t140 VSS 0.01939f
C2927 VDD.n2060 VSS 0.00646f
C2928 VDD.t130 VSS 0.01939f
C2929 VDD.n2061 VSS 0.00663f
C2930 VDD.n2062 VSS 0.00781f
C2931 VDD.t120 VSS 0.01939f
C2932 VDD.n2063 VSS 0.00647f
C2933 VDD.t110 VSS 0.01939f
C2934 VDD.n2064 VSS 0.00663f
C2935 VDD.n2065 VSS 0.01308f
C2936 VDD.n2066 VSS 0.01152f
C2937 VDD.t96 VSS 0.01996f
C2938 VDD.t106 VSS 0.01939f
C2939 VDD.n2067 VSS 0.00663f
C2940 VDD.n2068 VSS 0.01308f
C2941 VDD.n2069 VSS 0.01152f
C2942 VDD.n2070 VSS 0.01152f
C2943 VDD.n2071 VSS 0.01308f
C2944 VDD.n2072 VSS 0.00663f
C2945 VDD.n2073 VSS 0.00647f
C2946 VDD.t128 VSS 0.01939f
C2947 VDD.n2074 VSS 0.00663f
C2948 VDD.n2075 VSS 0.00781f
C2949 VDD.n2076 VSS 0.01152f
C2950 VDD.n2077 VSS 0.01152f
C2951 VDD.n2078 VSS 0.00781f
C2952 VDD.n2079 VSS 0.00663f
C2953 VDD.n2080 VSS 0.00647f
C2954 VDD.t146 VSS 0.01939f
C2955 VDD.n2081 VSS 0.00663f
C2956 VDD.n2082 VSS 0.00781f
C2957 VDD.n2083 VSS 0.01152f
C2958 VDD.n2084 VSS 0.01152f
C2959 VDD.n2085 VSS 0.00781f
C2960 VDD.n2086 VSS 0.00663f
C2961 VDD.n2087 VSS 0.00647f
C2962 VDD.n2088 VSS 0.00781f
C2963 VDD.n2089 VSS 0.00663f
C2964 VDD.n2090 VSS 0.00647f
C2965 VDD.t188 VSS 0.01939f
C2966 VDD.n2091 VSS 0.00663f
C2967 VDD.n2092 VSS 0.00781f
C2968 VDD.n2093 VSS 0.01152f
C2969 VDD.n2094 VSS 0.01152f
C2970 VDD.n2095 VSS 0.00781f
C2971 VDD.n2096 VSS 0.00663f
C2972 VDD.n2097 VSS 0.00646f
C2973 VDD.n2098 VSS 0.00781f
C2974 VDD.n2099 VSS 0.00663f
C2975 VDD.n2100 VSS 0.00646f
C2976 VDD.n2101 VSS 0.00781f
C2977 VDD.n2102 VSS 0.00663f
C2978 VDD.n2103 VSS 0.00646f
C2979 VDD.n2104 VSS 0.00781f
C2980 VDD.n2105 VSS 0.00663f
C2981 VDD.n2106 VSS 0.00646f
C2982 VDD.t270 VSS 0.01939f
C2983 VDD.n2107 VSS 0.00663f
C2984 VDD.n2108 VSS 0.00781f
C2985 VDD.n2109 VSS 0.01152f
C2986 VDD.t256 VSS 0.01939f
C2987 VDD.n2110 VSS 0.00646f
C2988 VDD.t286 VSS 0.01939f
C2989 VDD.n2111 VSS 0.00663f
C2990 VDD.n2112 VSS 0.00781f
C2991 VDD.t276 VSS 0.01939f
C2992 VDD.n2113 VSS 0.00646f
C2993 VDD.t266 VSS 0.01939f
C2994 VDD.n2114 VSS 0.00663f
C2995 VDD.n2115 VSS 0.00781f
C2996 VDD.n2116 VSS 0.01152f
C2997 VDD.n2117 VSS 0.01152f
C2998 VDD.n2118 VSS 0.00781f
C2999 VDD.t258 VSS 0.01939f
C3000 VDD.n2119 VSS 0.00647f
C3001 VDD.t248 VSS 0.01939f
C3002 VDD.n2120 VSS 0.00663f
C3003 VDD.n2121 VSS 0.00781f
C3004 VDD.n2122 VSS 0.01152f
C3005 VDD.n2123 VSS 0.01152f
C3006 VDD.n2124 VSS 0.00781f
C3007 VDD.t236 VSS 0.01939f
C3008 VDD.n2125 VSS 0.00646f
C3009 VDD.t226 VSS 0.01939f
C3010 VDD.n2126 VSS 0.00663f
C3011 VDD.n2127 VSS 0.00781f
C3012 VDD.n2128 VSS 0.01152f
C3013 VDD.n2129 VSS 0.01152f
C3014 VDD.n2130 VSS 0.00781f
C3015 VDD.t218 VSS 0.01939f
C3016 VDD.n2131 VSS 0.00647f
C3017 VDD.t208 VSS 0.01939f
C3018 VDD.n2132 VSS 0.00663f
C3019 VDD.n2133 VSS 0.00781f
C3020 VDD.n2134 VSS 0.01152f
C3021 VDD.n2135 VSS 0.01152f
C3022 VDD.n2136 VSS 0.00781f
C3023 VDD.t196 VSS 0.01939f
C3024 VDD.n2137 VSS 0.00646f
C3025 VDD.t186 VSS 0.01939f
C3026 VDD.n2138 VSS 0.00663f
C3027 VDD.n2139 VSS 0.00781f
C3028 VDD.t176 VSS 0.01939f
C3029 VDD.n2140 VSS 0.00646f
C3030 VDD.t166 VSS 0.01939f
C3031 VDD.n2141 VSS 0.00663f
C3032 VDD.n2142 VSS 0.00781f
C3033 VDD.n2143 VSS 0.01152f
C3034 VDD.n2144 VSS 0.00514f
C3035 VDD.n2145 VSS 0.00781f
C3036 VDD.t165 VSS 0.01735f
C3037 VDD.n2146 VSS 0.00662f
C3038 VDD.t175 VSS 0.01735f
C3039 VDD.n2147 VSS 0.00646f
C3040 VDD.t185 VSS 0.01735f
C3041 VDD.t195 VSS 0.01735f
C3042 VDD.t205 VSS 0.01735f
C3043 VDD.t215 VSS 0.01735f
C3044 VDD.t225 VSS 0.01735f
C3045 VDD.t235 VSS 0.01735f
C3046 VDD.t245 VSS 0.01735f
C3047 VDD.t255 VSS 0.01735f
C3048 VDD.t265 VSS 0.01735f
C3049 VDD.n2148 VSS 0.00662f
C3050 VDD.n2149 VSS 0.00781f
C3051 VDD.n2150 VSS 0.00646f
C3052 VDD.n2151 VSS 0.00662f
C3053 VDD.n2152 VSS 0.00781f
C3054 VDD.n2153 VSS 0.00646f
C3055 VDD.n2154 VSS 0.00662f
C3056 VDD.n2155 VSS 0.00781f
C3057 VDD.n2156 VSS 0.00646f
C3058 VDD.n2157 VSS 0.00662f
C3059 VDD.n2158 VSS 0.00781f
C3060 VDD.n2159 VSS 0.00646f
C3061 VDD.n2160 VSS 0.00662f
C3062 VDD.n2161 VSS 0.00781f
C3063 VDD.n2162 VSS 0.00514f
C3064 VDD.n2163 VSS 0.47308f
C3065 VDD.n2164 VSS 0.47308f
C3066 VDD.n2165 VSS 0.47308f
C3067 VDD.n2166 VSS 0.47308f
C3068 VDD.n2167 VSS 0.47308f
C3069 VDD.n2168 VSS 0.47308f
C3070 VDD.n2169 VSS 0.00514f
C3071 VDD.n2170 VSS 0.00781f
C3072 VDD.t285 VSS 0.01735f
C3073 VDD.n2171 VSS 0.00662f
C3074 VDD.t295 VSS 0.01735f
C3075 VDD.n2172 VSS 0.00646f
C3076 VDD.t305 VSS 0.01735f
C3077 VDD.t315 VSS 0.01735f
C3078 VDD.t325 VSS 0.01735f
C3079 VDD.n2173 VSS 0.00633f
C3080 VDD.n2174 VSS 0.00781f
C3081 VDD.n2175 VSS 0.00646f
C3082 VDD.n2176 VSS 0.00662f
C3083 VDD.n2177 VSS 0.00781f
C3084 VDD.n2178 VSS 0.00514f
C3085 VDD.n2179 VSS 0.01152f
C3086 VDD.n2180 VSS 0.00781f
C3087 VDD.n2181 VSS 0.00663f
C3088 VDD.n2182 VSS 0.00646f
C3089 VDD.t326 VSS 0.01939f
C3090 VDD.n2183 VSS 0.00633f
C3091 VDD.n2184 VSS 0.00781f
C3092 VDD.n2185 VSS 0.01152f
C3093 VDD.n2186 VSS 0.01152f
C3094 VDD.n2187 VSS 0.00781f
C3095 VDD.t318 VSS 0.01939f
C3096 VDD.n2188 VSS 0.00646f
C3097 VDD.t308 VSS 0.01939f
C3098 VDD.n2189 VSS 0.00663f
C3099 VDD.n2190 VSS 0.00781f
C3100 VDD.t298 VSS 0.01939f
C3101 VDD.n2191 VSS 0.00647f
C3102 VDD.t288 VSS 0.01939f
C3103 VDD.n2192 VSS 0.00663f
C3104 VDD.n2193 VSS 0.00781f
C3105 VDD.n2194 VSS 0.01152f
C3106 VDD.n2195 VSS 0.01152f
C3107 VDD.n2196 VSS 0.00781f
C3108 VDD.n2197 VSS 0.00663f
C3109 VDD.n2198 VSS 0.00646f
C3110 VDD.t330 VSS 0.01939f
C3111 VDD.n2199 VSS 0.00633f
C3112 VDD.n2200 VSS 0.00781f
C3113 VDD.t320 VSS 0.01939f
C3114 VDD.n2201 VSS 0.00646f
C3115 VDD.t310 VSS 0.01939f
C3116 VDD.n2202 VSS 0.00663f
C3117 VDD.n2203 VSS 0.00781f
C3118 VDD.n2204 VSS 0.01152f
C3119 VDD.n2205 VSS 0.01558f
C3120 VDD.n2206 VSS 0.00781f
C3121 VDD.n2207 VSS 0.00663f
C3122 VDD.n2208 VSS 0.00647f
C3123 VDD.t332 VSS 0.01939f
C3124 VDD.n2209 VSS 0.00633f
C3125 VDD.n2210 VSS 0.00781f
C3126 VDD.n2211 VSS 0.01558f
C3127 VDD.n2212 VSS 0.00835f
C3128 VDD.n2213 VSS 0.00633f
C3129 VDD.t344 VSS 0.01736f
C3130 VDD.n2214 VSS 0.01105f
C3131 VDD.n2215 VSS 0.02472f
C3132 VDD.n2216 VSS 0.01526f
C3133 VDD.n2217 VSS 0.01526f
C3134 VDD.n2218 VSS 0.01526f
C3135 VDD.n2219 VSS 0.07782f
C3136 VDD.n2220 VSS 0.53862f
C3137 VDD.n2221 VSS 0.23538f
C3138 VDD.n2222 VSS 0.03095f
C3139 VDD.n2223 VSS 0.02049f
C3140 VDD.n2224 VSS 0.01982f
C3141 VDD.n2225 VSS 0.17778f
C3142 VDD.t1 VSS 0.12483p
C3143 VDD.n2228 VSS 0.17778f
C3144 VDD.n2229 VSS 0.04843f
C3145 VDD.n2230 VSS 0.03091f
C3146 VDD.n2231 VSS 0.03998f
C3147 VDD.n2232 VSS 0.23538f
C3148 VDD.n2233 VSS 0.27904f
C3149 VDD.n2234 VSS 0.47308f
C3150 VDD.n2235 VSS 0.977f
C3151 VDD.n2236 VSS 0.66774f
C3152 VDD.n2237 VSS 0.02064f
C3153 VDD.n2238 VSS 0.0218f
C3154 VDD.n2239 VSS 0.07019f
C3155 VDD.n2240 VSS 0.02556f
C3156 VDD.n2241 VSS 0.02556f
C3157 VDD.n2242 VSS 0.02556f
C3158 VDD.n2243 VSS 0.01917f
C3159 VDD.n2244 VSS 0.01278f
C3160 VDD.n2245 VSS 0.74015f
C3161 Von.t158 VSS 2.75252f
C3162 Von.n0 VSS 1.14456f
C3163 Von.n1 VSS 0.02796f
C3164 Von.n2 VSS 0.6779f
C3165 Von.n3 VSS 0.02796f
C3166 Von.n4 VSS 0.02796f
C3167 Von.n5 VSS 0.02796f
C3168 Von.n6 VSS 0.6779f
C3169 Von.n7 VSS 0.03393f
C3170 Von.t136 VSS 0.05713f
C3171 Von.t130 VSS 0.05713f
C3172 Von.t135 VSS 0.05713f
C3173 Von.t122 VSS 0.05713f
C3174 Von.t126 VSS 0.05713f
C3175 Von.t50 VSS 0.05713f
C3176 Von.t35 VSS 0.05713f
C3177 Von.t43 VSS 0.05713f
C3178 Von.t98 VSS 0.05713f
C3179 Von.t70 VSS 0.05713f
C3180 Von.t76 VSS 0.05713f
C3181 Von.n8 VSS 0.019f
C3182 Von.n9 VSS 0.03393f
C3183 Von.t77 VSS 0.05713f
C3184 Von.n10 VSS 0.01901f
C3185 Von.t42 VSS 0.05713f
C3186 Von.n11 VSS 0.01957f
C3187 Von.n12 VSS 0.06851f
C3188 Von.t39 VSS 0.05713f
C3189 Von.n13 VSS 0.019f
C3190 Von.t46 VSS 0.05713f
C3191 Von.n14 VSS 0.01957f
C3192 Von.n15 VSS 0.03393f
C3193 Von.n16 VSS 0.02764f
C3194 Von.t36 VSS 0.05713f
C3195 Von.t79 VSS 0.05713f
C3196 Von.t38 VSS 0.05713f
C3197 Von.t74 VSS 0.05713f
C3198 Von.t71 VSS 0.05713f
C3199 Von.n17 VSS 0.01901f
C3200 Von.t106 VSS 0.05713f
C3201 Von.t103 VSS 0.05713f
C3202 Von.t91 VSS 0.05713f
C3203 Von.n18 VSS 0.019f
C3204 Von.n19 VSS 0.03393f
C3205 Von.t104 VSS 0.05713f
C3206 Von.t87 VSS 0.05713f
C3207 Von.t84 VSS 0.05713f
C3208 Von.n20 VSS 0.01901f
C3209 Von.n21 VSS 0.03393f
C3210 Von.t83 VSS 0.05713f
C3211 Von.t153 VSS 0.05713f
C3212 Von.t67 VSS 0.05713f
C3213 Von.n22 VSS 0.019f
C3214 Von.n23 VSS 0.03393f
C3215 Von.t149 VSS 0.05713f
C3216 Von.t144 VSS 0.05713f
C3217 Von.t112 VSS 0.05713f
C3218 Von.n24 VSS 0.01901f
C3219 Von.n25 VSS 0.03393f
C3220 Von.t111 VSS 0.05713f
C3221 Von.t68 VSS 0.05713f
C3222 Von.t114 VSS 0.05713f
C3223 Von.n26 VSS 0.01901f
C3224 Von.n27 VSS 0.03393f
C3225 Von.t95 VSS 0.05713f
C3226 Von.t57 VSS 0.05713f
C3227 Von.t31 VSS 0.05713f
C3228 Von.n28 VSS 0.01821f
C3229 Von.n29 VSS 0.03393f
C3230 Von.t30 VSS 0.05713f
C3231 Von.t66 VSS 0.05717f
C3232 Von.t51 VSS 0.05717f
C3233 Von.n30 VSS 0.02987f
C3234 Von.t75 VSS 0.05713f
C3235 Von.n31 VSS 0.01957f
C3236 Von.n32 VSS 0.02301f
C3237 Von.t72 VSS 0.05713f
C3238 Von.n33 VSS 0.019f
C3239 Von.t86 VSS 0.05713f
C3240 Von.n34 VSS 0.01957f
C3241 Von.n35 VSS 0.02301f
C3242 Von.t105 VSS 0.05713f
C3243 Von.n36 VSS 0.019f
C3244 Von.t88 VSS 0.05713f
C3245 Von.n37 VSS 0.01957f
C3246 Von.n38 VSS 0.02301f
C3247 Von.t142 VSS 0.05713f
C3248 Von.n39 VSS 0.019f
C3249 Von.t148 VSS 0.05713f
C3250 Von.n40 VSS 0.01957f
C3251 Von.n41 VSS 0.02301f
C3252 Von.t150 VSS 0.05713f
C3253 Von.n42 VSS 0.019f
C3254 Von.t145 VSS 0.05713f
C3255 Von.n43 VSS 0.01957f
C3256 Von.n44 VSS 0.02301f
C3257 Von.t108 VSS 0.05713f
C3258 Von.n45 VSS 0.019f
C3259 Von.t116 VSS 0.05713f
C3260 Von.n46 VSS 0.01957f
C3261 Von.n47 VSS 0.02301f
C3262 Von.t96 VSS 0.05713f
C3263 Von.n48 VSS 0.019f
C3264 Von.t55 VSS 0.05713f
C3265 Von.n49 VSS 0.01957f
C3266 Von.n50 VSS 0.023f
C3267 Von.t118 VSS 0.05713f
C3268 Von.n51 VSS 0.01821f
C3269 Von.t52 VSS 0.05717f
C3270 Von.n52 VSS 0.02987f
C3271 Von.t58 VSS 0.05717f
C3272 Von.n53 VSS 0.02987f
C3273 Von.t59 VSS 0.05717f
C3274 Von.n54 VSS 0.02986f
C3275 Von.n55 VSS 0.02796f
C3276 Von.n56 VSS 0.02796f
C3277 Von.n57 VSS 0.02796f
C3278 Von.n58 VSS 0.06002f
C3279 Von.n59 VSS 0.07533f
C3280 Von.n60 VSS 0.07533f
C3281 Von.t155 VSS 5.9626f
C3282 Von.n61 VSS 0.29651f
C3283 Von.n62 VSS 0.06083f
C3284 Von.n63 VSS 0.07533f
C3285 Von.n64 VSS 0.07533f
C3286 Von.n65 VSS 0.20685f
C3287 Von.n66 VSS 0.06465f
C3288 Von.n67 VSS 0.06043f
C3289 Von.n68 VSS 0.02796f
C3290 Von.n69 VSS 0.02796f
C3291 Von.t81 VSS 0.05713f
C3292 Von.t89 VSS 0.05713f
C3293 Von.t93 VSS 0.05713f
C3294 Von.t143 VSS 0.05713f
C3295 Von.t151 VSS 0.05713f
C3296 Von.t100 VSS 0.05713f
C3297 Von.t109 VSS 0.05713f
C3298 Von.t80 VSS 0.05713f
C3299 Von.t53 VSS 0.05713f
C3300 Von.t33 VSS 0.05713f
C3301 Von.t119 VSS 0.05713f
C3302 Von.n70 VSS 0.01821f
C3303 Von.n71 VSS 0.03393f
C3304 Von.n72 VSS 0.023f
C3305 Von.n73 VSS 0.01957f
C3306 Von.n74 VSS 0.01901f
C3307 Von.n75 VSS 0.03393f
C3308 Von.n76 VSS 0.023f
C3309 Von.n77 VSS 0.01957f
C3310 Von.n78 VSS 0.01901f
C3311 Von.n79 VSS 0.03393f
C3312 Von.n80 VSS 0.023f
C3313 Von.n81 VSS 0.01957f
C3314 Von.n82 VSS 0.01901f
C3315 Von.n83 VSS 0.03393f
C3316 Von.n84 VSS 0.023f
C3317 Von.n85 VSS 0.01957f
C3318 Von.n86 VSS 0.01901f
C3319 Von.n87 VSS 0.03393f
C3320 Von.n88 VSS 0.023f
C3321 Von.n89 VSS 0.01957f
C3322 Von.n90 VSS 0.01901f
C3323 Von.t102 VSS 0.05713f
C3324 Von.n91 VSS 0.01957f
C3325 Von.n92 VSS 0.023f
C3326 Von.n93 VSS 0.03393f
C3327 Von.t82 VSS 0.05713f
C3328 Von.t146 VSS 0.05713f
C3329 Von.t94 VSS 0.05713f
C3330 Von.t90 VSS 0.05713f
C3331 Von.t152 VSS 0.05713f
C3332 Von.t101 VSS 0.05713f
C3333 Von.t110 VSS 0.05713f
C3334 Von.t56 VSS 0.05713f
C3335 Von.t54 VSS 0.05713f
C3336 Von.t32 VSS 0.05713f
C3337 Von.t117 VSS 0.05713f
C3338 Von.n94 VSS 0.0182f
C3339 Von.n95 VSS 0.02301f
C3340 Von.n96 VSS 0.01957f
C3341 Von.n97 VSS 0.019f
C3342 Von.n98 VSS 0.02301f
C3343 Von.n99 VSS 0.01957f
C3344 Von.n100 VSS 0.019f
C3345 Von.n101 VSS 0.02301f
C3346 Von.n102 VSS 0.01957f
C3347 Von.n103 VSS 0.019f
C3348 Von.n104 VSS 0.02301f
C3349 Von.n105 VSS 0.01957f
C3350 Von.n106 VSS 0.019f
C3351 Von.n107 VSS 0.02301f
C3352 Von.n108 VSS 0.01957f
C3353 Von.n109 VSS 0.019f
C3354 Von.t107 VSS 0.05713f
C3355 Von.n110 VSS 0.01957f
C3356 Von.n111 VSS 0.02301f
C3357 Von.n112 VSS 0.02796f
C3358 Von.n113 VSS 1.40685f
C3359 Von.n114 VSS 1.40685f
C3360 Von.n115 VSS 0.97775f
C3361 Von.n116 VSS 0.69359f
C3362 Von.n117 VSS 1.14237f
C3363 Von.n118 VSS 1.40685f
C3364 Von.n119 VSS 1.96982f
C3365 Von.n120 VSS 0.12539f
C3366 Von.n121 VSS 0.04504f
C3367 Von.n122 VSS 0.04504f
C3368 Von.n123 VSS 0.08804f
C3369 Von.n124 VSS 0.03536f
C3370 Von.n125 VSS 0.01821f
C3371 Von.t113 VSS 0.05713f
C3372 Von.n126 VSS 0.01957f
C3373 Von.n127 VSS 0.02763f
C3374 Von.n128 VSS 0.06851f
C3375 Von.n129 VSS 0.023f
C3376 Von.n130 VSS 0.01957f
C3377 Von.n131 VSS 0.01901f
C3378 Von.t115 VSS 0.05713f
C3379 Von.n132 VSS 0.01957f
C3380 Von.n133 VSS 0.023f
C3381 Von.n134 VSS 0.06851f
C3382 Von.n135 VSS 0.02763f
C3383 Von.n136 VSS 0.01957f
C3384 Von.n137 VSS 0.019f
C3385 Von.t147 VSS 0.05713f
C3386 Von.n138 VSS 0.01957f
C3387 Von.n139 VSS 0.02764f
C3388 Von.n140 VSS 0.06851f
C3389 Von.n141 VSS 0.023f
C3390 Von.n142 VSS 0.01957f
C3391 Von.n143 VSS 0.01901f
C3392 Von.t154 VSS 0.05713f
C3393 Von.n144 VSS 0.01957f
C3394 Von.n145 VSS 0.023f
C3395 Von.n146 VSS 0.06851f
C3396 Von.n147 VSS 0.02764f
C3397 Von.n148 VSS 0.01957f
C3398 Von.n149 VSS 0.019f
C3399 Von.t92 VSS 0.05713f
C3400 Von.n150 VSS 0.01957f
C3401 Von.n151 VSS 0.02764f
C3402 Von.n152 VSS 0.06851f
C3403 Von.n153 VSS 0.023f
C3404 Von.n154 VSS 0.01957f
C3405 Von.n155 VSS 0.01901f
C3406 Von.t85 VSS 0.05713f
C3407 Von.n156 VSS 0.01957f
C3408 Von.n157 VSS 0.023f
C3409 Von.n158 VSS 0.06851f
C3410 Von.n159 VSS 0.02764f
C3411 Von.n160 VSS 0.01957f
C3412 Von.n161 VSS 0.019f
C3413 Von.t40 VSS 0.05713f
C3414 Von.n162 VSS 0.019f
C3415 Von.t78 VSS 0.05713f
C3416 Von.n163 VSS 0.01957f
C3417 Von.n164 VSS 0.02764f
C3418 Von.t73 VSS 0.05713f
C3419 Von.n165 VSS 0.019f
C3420 Von.t41 VSS 0.05713f
C3421 Von.n166 VSS 0.01957f
C3422 Von.n167 VSS 0.02764f
C3423 Von.n168 VSS 0.06851f
C3424 Von.n169 VSS 0.023f
C3425 Von.n170 VSS 0.01957f
C3426 Von.n171 VSS 0.01901f
C3427 Von.n172 VSS 0.023f
C3428 Von.n173 VSS 0.01957f
C3429 Von.n174 VSS 0.01901f
C3430 Von.t134 VSS 0.05713f
C3431 Von.n175 VSS 0.01957f
C3432 Von.n176 VSS 0.03393f
C3433 Von.t132 VSS 0.05713f
C3434 Von.t44 VSS 0.05713f
C3435 Von.n177 VSS 0.01957f
C3436 Von.n178 VSS 0.019f
C3437 Von.t128 VSS 0.05713f
C3438 Von.n179 VSS 0.01957f
C3439 Von.t121 VSS 0.05713f
C3440 Von.t131 VSS 0.05713f
C3441 Von.t125 VSS 0.05713f
C3442 Von.t47 VSS 0.05713f
C3443 Von.t34 VSS 0.05713f
C3444 Von.n180 VSS 0.01901f
C3445 Von.n181 VSS 0.023f
C3446 Von.n182 VSS 0.01957f
C3447 Von.n183 VSS 0.01901f
C3448 Von.n184 VSS 0.03393f
C3449 Von.n185 VSS 0.023f
C3450 Von.n186 VSS 0.01957f
C3451 Von.n187 VSS 0.01901f
C3452 Von.t141 VSS 0.05898f
C3453 Von.n188 VSS 0.03888f
C3454 Von.t62 VSS 0.05713f
C3455 Von.n189 VSS 0.01901f
C3456 Von.t129 VSS 0.05713f
C3457 Von.n190 VSS 0.01957f
C3458 Von.n191 VSS 0.023f
C3459 Von.n192 VSS 0.03393f
C3460 Von.n193 VSS 0.03393f
C3461 Von.t127 VSS 0.05713f
C3462 Von.n194 VSS 0.01901f
C3463 Von.t138 VSS 0.05898f
C3464 Von.t61 VSS 0.05713f
C3465 Von.t64 VSS 0.05713f
C3466 Von.t120 VSS 0.05713f
C3467 Von.t133 VSS 0.05713f
C3468 Von.t49 VSS 0.05713f
C3469 Von.n195 VSS 0.019f
C3470 Von.n196 VSS 0.02301f
C3471 Von.n197 VSS 0.01957f
C3472 Von.n198 VSS 0.019f
C3473 Von.n199 VSS 0.02301f
C3474 Von.n200 VSS 0.01957f
C3475 Von.n201 VSS 0.019f
C3476 Von.t140 VSS 0.05898f
C3477 Von.n202 VSS 0.03889f
C3478 Von.n203 VSS 0.03393f
C3479 Von.t137 VSS 0.05713f
C3480 Von.n204 VSS 0.019f
C3481 Von.t65 VSS 0.05898f
C3482 Von.n205 VSS 0.04352f
C3483 Von.n206 VSS 0.06851f
C3484 Von.n207 VSS 0.03889f
C3485 Von.t60 VSS 0.05713f
C3486 Von.n208 VSS 0.019f
C3487 Von.t63 VSS 0.05713f
C3488 Von.n209 VSS 0.01957f
C3489 Von.n210 VSS 0.023f
C3490 Von.n211 VSS 0.06851f
C3491 Von.n212 VSS 0.02764f
C3492 Von.t123 VSS 0.05713f
C3493 Von.n213 VSS 0.019f
C3494 Von.t124 VSS 0.05713f
C3495 Von.n214 VSS 0.01957f
C3496 Von.n215 VSS 0.02764f
C3497 Von.n216 VSS 0.06851f
C3498 Von.n217 VSS 0.023f
C3499 Von.t48 VSS 0.05713f
C3500 Von.n218 VSS 0.01901f
C3501 Von.t45 VSS 0.05713f
C3502 Von.n219 VSS 0.01957f
C3503 Von.n220 VSS 0.023f
C3504 Von.n221 VSS 0.06851f
C3505 Von.n222 VSS 0.03393f
C3506 Von.n223 VSS 0.02301f
C3507 Von.t37 VSS 0.05713f
C3508 Von.n224 VSS 0.019f
C3509 Von.t97 VSS 0.05713f
C3510 Von.n225 VSS 0.01957f
C3511 Von.n226 VSS 0.02301f
C3512 Von.n227 VSS 0.03393f
C3513 Von.n228 VSS 0.03393f
C3514 Von.n229 VSS 0.023f
C3515 Von.t99 VSS 0.05713f
C3516 Von.n230 VSS 0.01901f
C3517 Von.t69 VSS 0.05713f
C3518 Von.n231 VSS 0.01957f
C3519 Von.n232 VSS 0.023f
C3520 Von.n233 VSS 0.03393f
C3521 Von.n234 VSS 0.02796f
C3522 Von.n235 VSS 0.02301f
C3523 Von.n236 VSS 0.01957f
C3524 Von.n237 VSS 0.019f
C3525 Von.n238 VSS 0.02301f
C3526 Von.n239 VSS 0.01957f
C3527 Von.n240 VSS 0.019f
C3528 Von.n241 VSS 0.02301f
C3529 Von.n242 VSS 0.01957f
C3530 Von.n243 VSS 0.019f
C3531 Von.n244 VSS 0.02301f
C3532 Von.n245 VSS 0.01957f
C3533 Von.n246 VSS 0.019f
C3534 Von.n247 VSS 0.02301f
C3535 Von.n248 VSS 0.01957f
C3536 Von.n249 VSS 0.019f
C3537 Von.t139 VSS 0.05898f
C3538 Von.n250 VSS 0.03889f
C3539 Von.n251 VSS 0.02796f
C3540 Von.n252 VSS 0.61423f
C3541 Von.t12 VSS 0.2008f
C3542 Von.t6 VSS 0.20018f
C3543 Von.t19 VSS 0.20018f
C3544 Von.n253 VSS 0.06303f
C3545 Von.n254 VSS 1.19711f
C3546 Von.t10 VSS 0.20018f
C3547 Von.t25 VSS 0.20018f
C3548 Von.t13 VSS 0.23673f
C3549 Von.n255 VSS 2.36986f
C3550 Von.t29 VSS 0.23673f
C3551 Von.t28 VSS 0.2008f
C3552 Von.n256 VSS 0.11445f
C3553 Von.t20 VSS 0.2008f
C3554 Von.t4 VSS 0.20018f
C3555 Von.t22 VSS 0.20018f
C3556 Von.t15 VSS 0.20018f
C3557 Von.t14 VSS 0.23673f
C3558 Von.n257 VSS 0.09633f
C3559 Von.n258 VSS 0.06309f
C3560 Von.n259 VSS 0.06307f
C3561 Von.t23 VSS 0.20018f
C3562 Von.t2 VSS 0.20018f
C3563 Von.t7 VSS 0.23673f
C3564 Von.n260 VSS 0.18323f
C3565 Von.n261 VSS 0.06313f
C3566 Von.n262 VSS 0.06303f
C3567 Von.t26 VSS 0.20018f
C3568 Von.n263 VSS 0.06202f
C3569 Von.n264 VSS 0.15853f
C3570 Von.n265 VSS 2.36986f
C3571 Von.n266 VSS 0.07162f
C3572 Von.n267 VSS 0.06199f
C3573 Von.n268 VSS 0.08258f
C3574 Von.n269 VSS 1.22785f
C3575 Von.n270 VSS 0.61423f
C3576 Von.t9 VSS 0.2008f
C3577 Von.n271 VSS 0.08258f
C3578 Von.t3 VSS 0.20018f
C3579 Von.n272 VSS 0.06199f
C3580 Von.n273 VSS 0.07163f
C3581 Von.t11 VSS 0.20018f
C3582 Von.n274 VSS 0.06303f
C3583 Von.t21 VSS 0.20018f
C3584 Von.n275 VSS 0.06313f
C3585 Von.n276 VSS 0.09632f
C3586 Von.n277 VSS 1.19711f
C3587 Von.t1 VSS 0.23673f
C3588 Von.t24 VSS 0.20018f
C3589 Von.n278 VSS 0.06313f
C3590 Von.n279 VSS 0.09632f
C3591 Von.n280 VSS 1.19711f
C3592 Von.n281 VSS 1.19711f
C3593 Von.n282 VSS 0.09632f
C3594 Von.n283 VSS 0.06313f
C3595 Von.n284 VSS 0.06303f
C3596 Von.t8 VSS 0.2008f
C3597 Von.n285 VSS 0.08258f
C3598 Von.t17 VSS 0.20018f
C3599 Von.n286 VSS 0.06199f
C3600 Von.n287 VSS 0.07163f
C3601 Von.n288 VSS 1.19711f
C3602 Von.n289 VSS 1.19711f
C3603 Von.n290 VSS 0.07163f
C3604 Von.n291 VSS 0.06199f
C3605 Von.n292 VSS 0.08258f
C3606 Von.n293 VSS 0.61423f
C3607 Von.t5 VSS 0.1791f
C3608 Von.t0 VSS 0.21563f
C3609 Von.n294 VSS 0.09636f
C3610 Von.t27 VSS 0.1791f
C3611 Von.n295 VSS 0.06312f
C3612 Von.t18 VSS 0.1791f
C3613 Von.n296 VSS 0.06302f
C3614 Von.n297 VSS 0.07164f
C3615 Von.n298 VSS 0.06199f
C3616 Von.t16 VSS 0.17973f
C3617 Von.n299 VSS 0.08258f
C3618 Von.n300 VSS 2.5688f
C3619 Von.n301 VSS 2.19208f
C3620 Von.n302 VSS 0.77491f
C3621 Von.n303 VSS 1.39807f
C3622 Von.n304 VSS 1.40685f
C3623 Von.n305 VSS 0.84057f
C3624 Von.n306 VSS 0.77491f
C3625 Von.n307 VSS 0.84825f
C3626 Von.n308 VSS 0.85427f
C3627 Von.t156 VSS 0.06998f
C3628 Von.n309 VSS 3.12927f
C3629 Von.t157 VSS 10.0924f
C3630 Von.n310 VSS 2.15814f
C3631 VNout.t1 VSS 0.01916f
C3632 VNout.t0 VSS 0.01917f
C3633 VNout.n0 VSS 0.803f
C3634 Vop.t156 VSS 0.06817f
C3635 Vop.n0 VSS 1.116f
C3636 Vop.n1 VSS 0.02727f
C3637 Vop.n2 VSS 0.66098f
C3638 Vop.n3 VSS 0.02727f
C3639 Vop.n4 VSS 0.02727f
C3640 Vop.n5 VSS 0.02727f
C3641 Vop.n6 VSS 0.66098f
C3642 Vop.n7 VSS 0.03309f
C3643 Vop.t38 VSS 0.05571f
C3644 Vop.t39 VSS 0.05571f
C3645 Vop.t41 VSS 0.05571f
C3646 Vop.t68 VSS 0.05571f
C3647 Vop.t83 VSS 0.05571f
C3648 Vop.t84 VSS 0.05571f
C3649 Vop.t139 VSS 0.05571f
C3650 Vop.t70 VSS 0.05571f
C3651 Vop.t61 VSS 0.05571f
C3652 Vop.t80 VSS 0.05571f
C3653 Vop.t64 VSS 0.05571f
C3654 Vop.n8 VSS 0.01854f
C3655 Vop.n9 VSS 0.03309f
C3656 Vop.t65 VSS 0.05571f
C3657 Vop.n10 VSS 0.01852f
C3658 Vop.t71 VSS 0.05571f
C3659 Vop.n11 VSS 0.01908f
C3660 Vop.n12 VSS 0.0668f
C3661 Vop.t60 VSS 0.05571f
C3662 Vop.n13 VSS 0.01854f
C3663 Vop.t138 VSS 0.05571f
C3664 Vop.n14 VSS 0.01908f
C3665 Vop.n15 VSS 0.0668f
C3666 Vop.t66 VSS 0.05571f
C3667 Vop.n16 VSS 0.01852f
C3668 Vop.t69 VSS 0.05571f
C3669 Vop.n17 VSS 0.01908f
C3670 Vop.n18 VSS 0.0668f
C3671 Vop.t137 VSS 0.05571f
C3672 Vop.n19 VSS 0.01854f
C3673 Vop.t33 VSS 0.05571f
C3674 Vop.n20 VSS 0.01908f
C3675 Vop.n21 VSS 0.02694f
C3676 Vop.t148 VSS 0.05571f
C3677 Vop.t135 VSS 0.05571f
C3678 Vop.t146 VSS 0.05571f
C3679 Vop.t133 VSS 0.05571f
C3680 Vop.t81 VSS 0.05571f
C3681 Vop.t56 VSS 0.05571f
C3682 Vop.t78 VSS 0.05571f
C3683 Vop.t54 VSS 0.05571f
C3684 Vop.t92 VSS 0.05571f
C3685 Vop.n22 VSS 0.01852f
C3686 Vop.t151 VSS 0.05571f
C3687 Vop.t58 VSS 0.05571f
C3688 Vop.t90 VSS 0.05571f
C3689 Vop.n23 VSS 0.01854f
C3690 Vop.n24 VSS 0.03309f
C3691 Vop.t77 VSS 0.05571f
C3692 Vop.t89 VSS 0.05571f
C3693 Vop.t105 VSS 0.05571f
C3694 Vop.n25 VSS 0.01852f
C3695 Vop.t143 VSS 0.05571f
C3696 Vop.n26 VSS 0.01908f
C3697 Vop.n27 VSS 0.02694f
C3698 Vop.n28 VSS 0.03309f
C3699 Vop.t145 VSS 0.05571f
C3700 Vop.t100 VSS 0.05571f
C3701 Vop.t126 VSS 0.05571f
C3702 Vop.n29 VSS 0.01854f
C3703 Vop.n30 VSS 0.0668f
C3704 Vop.n31 VSS 0.02727f
C3705 Vop.t120 VSS 0.05571f
C3706 Vop.n32 VSS 0.01852f
C3707 Vop.t72 VSS 0.05571f
C3708 Vop.n33 VSS 0.01908f
C3709 Vop.n34 VSS 1.37174f
C3710 Vop.t141 VSS 0.05571f
C3711 Vop.t86 VSS 0.05571f
C3712 Vop.t131 VSS 0.05571f
C3713 Vop.n35 VSS 0.01854f
C3714 Vop.n36 VSS 0.02727f
C3715 Vop.n37 VSS 0.02727f
C3716 Vop.n38 VSS 0.02727f
C3717 Vop.t47 VSS 0.05574f
C3718 Vop.t104 VSS 0.05571f
C3719 Vop.n39 VSS 0.01908f
C3720 Vop.n40 VSS 0.02243f
C3721 Vop.t119 VSS 0.05571f
C3722 Vop.n41 VSS 0.01854f
C3723 Vop.t125 VSS 0.05571f
C3724 Vop.n42 VSS 0.01908f
C3725 Vop.n43 VSS 0.02243f
C3726 Vop.t124 VSS 0.05571f
C3727 Vop.n44 VSS 0.01854f
C3728 Vop.t110 VSS 0.05571f
C3729 Vop.n45 VSS 0.01908f
C3730 Vop.n46 VSS 0.02243f
C3731 Vop.t116 VSS 0.05571f
C3732 Vop.n47 VSS 0.01854f
C3733 Vop.t49 VSS 0.05571f
C3734 Vop.n48 VSS 0.01908f
C3735 Vop.n49 VSS 0.02243f
C3736 Vop.t106 VSS 0.05571f
C3737 Vop.n50 VSS 0.01776f
C3738 Vop.n51 VSS 0.02912f
C3739 Vop.t48 VSS 0.05574f
C3740 Vop.n52 VSS 0.02912f
C3741 Vop.t153 VSS 0.05574f
C3742 Vop.n53 VSS 0.02912f
C3743 Vop.t45 VSS 0.05574f
C3744 Vop.n54 VSS 0.02912f
C3745 Vop.t115 VSS 0.05571f
C3746 Vop.n55 VSS 0.01908f
C3747 Vop.n56 VSS 0.03309f
C3748 Vop.t43 VSS 0.05571f
C3749 Vop.n57 VSS 0.01775f
C3750 Vop.t121 VSS 0.05571f
C3751 Vop.n58 VSS 0.01908f
C3752 Vop.t108 VSS 0.05571f
C3753 Vop.n59 VSS 0.01854f
C3754 Vop.n60 VSS 0.02694f
C3755 Vop.n61 VSS 0.03309f
C3756 Vop.t123 VSS 0.05571f
C3757 Vop.t109 VSS 0.05571f
C3758 Vop.t51 VSS 0.05571f
C3759 Vop.n62 VSS 0.01776f
C3760 Vop.n63 VSS 0.02243f
C3761 Vop.n64 VSS 0.01908f
C3762 Vop.n65 VSS 0.01854f
C3763 Vop.t94 VSS 0.05571f
C3764 Vop.n66 VSS 0.01908f
C3765 Vop.t118 VSS 0.05571f
C3766 Vop.t122 VSS 0.05571f
C3767 Vop.n67 VSS 0.01908f
C3768 Vop.n68 VSS 0.01854f
C3769 Vop.t101 VSS 0.05571f
C3770 Vop.n69 VSS 0.01854f
C3771 Vop.t142 VSS 0.05571f
C3772 Vop.n70 VSS 0.01908f
C3773 Vop.n71 VSS 0.02694f
C3774 Vop.t98 VSS 0.05571f
C3775 Vop.n72 VSS 0.01854f
C3776 Vop.t102 VSS 0.05571f
C3777 Vop.n73 VSS 0.01908f
C3778 Vop.n74 VSS 0.02694f
C3779 Vop.t112 VSS 0.05571f
C3780 Vop.n75 VSS 0.01852f
C3781 Vop.t103 VSS 0.05571f
C3782 Vop.n76 VSS 0.01908f
C3783 Vop.n77 VSS 0.02243f
C3784 Vop.t97 VSS 0.05571f
C3785 Vop.n78 VSS 0.01852f
C3786 Vop.t95 VSS 0.05571f
C3787 Vop.n79 VSS 0.01908f
C3788 Vop.n80 VSS 0.02243f
C3789 Vop.n81 VSS 0.0668f
C3790 Vop.t117 VSS 0.05571f
C3791 Vop.t113 VSS 0.05571f
C3792 Vop.t154 VSS 0.05571f
C3793 Vop.t96 VSS 0.05571f
C3794 Vop.t50 VSS 0.05571f
C3795 Vop.n82 VSS 0.01776f
C3796 Vop.n83 VSS 0.03309f
C3797 Vop.n84 VSS 0.02243f
C3798 Vop.n85 VSS 0.01908f
C3799 Vop.n86 VSS 0.01852f
C3800 Vop.n87 VSS 0.02243f
C3801 Vop.n88 VSS 0.01908f
C3802 Vop.n89 VSS 0.01852f
C3803 Vop.t127 VSS 0.05571f
C3804 Vop.n90 VSS 0.01908f
C3805 Vop.n91 VSS 0.02243f
C3806 Vop.n92 VSS 0.03309f
C3807 Vop.n93 VSS 0.03309f
C3808 Vop.n94 VSS 0.02243f
C3809 Vop.t111 VSS 0.05571f
C3810 Vop.n95 VSS 0.01854f
C3811 Vop.t155 VSS 0.05571f
C3812 Vop.n96 VSS 0.01908f
C3813 Vop.n97 VSS 0.02243f
C3814 Vop.n98 VSS 0.03309f
C3815 Vop.n99 VSS 0.0668f
C3816 Vop.n100 VSS 0.02243f
C3817 Vop.t107 VSS 0.05571f
C3818 Vop.n101 VSS 0.01852f
C3819 Vop.t114 VSS 0.05571f
C3820 Vop.n102 VSS 0.01908f
C3821 Vop.n103 VSS 0.02243f
C3822 Vop.n104 VSS 0.0668f
C3823 Vop.n105 VSS 0.02694f
C3824 Vop.t44 VSS 0.05571f
C3825 Vop.n106 VSS 0.01776f
C3826 Vop.t46 VSS 0.05574f
C3827 Vop.n107 VSS 0.03448f
C3828 Vop.n108 VSS 0.08584f
C3829 Vop.n109 VSS 0.04391f
C3830 Vop.n110 VSS 0.04391f
C3831 Vop.n111 VSS 0.12226f
C3832 Vop.n112 VSS 1.92067f
C3833 Vop.n113 VSS 1.37174f
C3834 Vop.n114 VSS 1.11386f
C3835 Vop.n115 VSS 0.05892f
C3836 Vop.n116 VSS 0.07345f
C3837 Vop.n117 VSS 0.07345f
C3838 Vop.n118 VSS 0.07345f
C3839 Vop.n119 VSS 0.07345f
C3840 Vop.n120 VSS 0.06303f
C3841 Vop.n121 VSS 0.20168f
C3842 Vop.t30 VSS 5.8138f
C3843 Vop.n122 VSS 0.28911f
C3844 Vop.n123 VSS 0.05931f
C3845 Vop.n124 VSS 0.05852f
C3846 Vop.n125 VSS 0.67628f
C3847 Vop.n126 VSS 0.95335f
C3848 Vop.n127 VSS 1.37174f
C3849 Vop.n128 VSS 0.02727f
C3850 Vop.n129 VSS 0.02243f
C3851 Vop.n130 VSS 0.01908f
C3852 Vop.n131 VSS 0.01854f
C3853 Vop.t74 VSS 0.05571f
C3854 Vop.n132 VSS 0.01908f
C3855 Vop.n133 VSS 0.02243f
C3856 Vop.n134 VSS 0.02727f
C3857 Vop.n135 VSS 0.03309f
C3858 Vop.n136 VSS 0.02243f
C3859 Vop.t75 VSS 0.05571f
C3860 Vop.n137 VSS 0.01852f
C3861 Vop.t87 VSS 0.05571f
C3862 Vop.n138 VSS 0.01908f
C3863 Vop.n139 VSS 0.02243f
C3864 Vop.t144 VSS 0.05571f
C3865 Vop.n140 VSS 0.01852f
C3866 Vop.t99 VSS 0.05571f
C3867 Vop.n141 VSS 0.01908f
C3868 Vop.n142 VSS 0.02243f
C3869 Vop.n143 VSS 0.03309f
C3870 Vop.n144 VSS 0.03309f
C3871 Vop.n145 VSS 0.02243f
C3872 Vop.n146 VSS 0.01908f
C3873 Vop.n147 VSS 0.01854f
C3874 Vop.t63 VSS 0.05571f
C3875 Vop.n148 VSS 0.01908f
C3876 Vop.n149 VSS 0.02243f
C3877 Vop.t91 VSS 0.05571f
C3878 Vop.n150 VSS 0.01854f
C3879 Vop.t73 VSS 0.05571f
C3880 Vop.n151 VSS 0.01908f
C3881 Vop.n152 VSS 0.02243f
C3882 Vop.t76 VSS 0.05571f
C3883 Vop.n153 VSS 0.01854f
C3884 Vop.t88 VSS 0.05571f
C3885 Vop.n154 VSS 0.01908f
C3886 Vop.n155 VSS 0.02243f
C3887 Vop.n156 VSS 0.03309f
C3888 Vop.n157 VSS 0.0668f
C3889 Vop.n158 VSS 0.02243f
C3890 Vop.n159 VSS 0.01908f
C3891 Vop.n160 VSS 0.01852f
C3892 Vop.t57 VSS 0.05571f
C3893 Vop.n161 VSS 0.01908f
C3894 Vop.n162 VSS 0.02243f
C3895 Vop.n163 VSS 0.0668f
C3896 Vop.n164 VSS 0.02694f
C3897 Vop.n165 VSS 0.01908f
C3898 Vop.n166 VSS 0.01854f
C3899 Vop.t36 VSS 0.05571f
C3900 Vop.n167 VSS 0.01854f
C3901 Vop.t42 VSS 0.05571f
C3902 Vop.n168 VSS 0.01908f
C3903 Vop.n169 VSS 0.02694f
C3904 Vop.t149 VSS 0.05571f
C3905 Vop.n170 VSS 0.01854f
C3906 Vop.t132 VSS 0.05571f
C3907 Vop.n171 VSS 0.01908f
C3908 Vop.n172 VSS 0.02694f
C3909 Vop.t82 VSS 0.05571f
C3910 Vop.n173 VSS 0.01854f
C3911 Vop.t93 VSS 0.05571f
C3912 Vop.n174 VSS 0.01908f
C3913 Vop.n175 VSS 0.02694f
C3914 Vop.t79 VSS 0.05571f
C3915 Vop.n176 VSS 0.01854f
C3916 Vop.t53 VSS 0.05571f
C3917 Vop.n177 VSS 0.01908f
C3918 Vop.n178 VSS 0.02694f
C3919 Vop.n179 VSS 0.0668f
C3920 Vop.n180 VSS 0.02243f
C3921 Vop.n181 VSS 0.01908f
C3922 Vop.n182 VSS 0.01852f
C3923 Vop.n183 VSS 0.02243f
C3924 Vop.n184 VSS 0.01908f
C3925 Vop.n185 VSS 0.01852f
C3926 Vop.n186 VSS 0.02243f
C3927 Vop.n187 VSS 0.01908f
C3928 Vop.n188 VSS 0.01852f
C3929 Vop.n189 VSS 0.02243f
C3930 Vop.n190 VSS 0.01908f
C3931 Vop.n191 VSS 0.01852f
C3932 Vop.t37 VSS 0.05751f
C3933 Vop.t152 VSS 0.05571f
C3934 Vop.t32 VSS 0.05571f
C3935 Vop.n192 VSS 0.01908f
C3936 Vop.n193 VSS 0.01854f
C3937 Vop.t128 VSS 0.05751f
C3938 Vop.n194 VSS 0.04242f
C3939 Vop.t129 VSS 0.05571f
C3940 Vop.n195 VSS 0.01852f
C3941 Vop.t35 VSS 0.05751f
C3942 Vop.n196 VSS 0.03792f
C3943 Vop.n197 VSS 0.03309f
C3944 Vop.n198 VSS 0.0668f
C3945 Vop.n199 VSS 0.03792f
C3946 Vop.t130 VSS 0.05571f
C3947 Vop.n200 VSS 0.01852f
C3948 Vop.t31 VSS 0.05571f
C3949 Vop.n201 VSS 0.01908f
C3950 Vop.n202 VSS 0.02243f
C3951 Vop.n203 VSS 0.0668f
C3952 Vop.t140 VSS 0.05571f
C3953 Vop.n204 VSS 0.01852f
C3954 Vop.t34 VSS 0.05751f
C3955 Vop.n205 VSS 0.03792f
C3956 Vop.t150 VSS 0.05571f
C3957 Vop.n206 VSS 0.01852f
C3958 Vop.t40 VSS 0.05571f
C3959 Vop.n207 VSS 0.01908f
C3960 Vop.n208 VSS 0.02243f
C3961 Vop.n209 VSS 0.03309f
C3962 Vop.n210 VSS 0.03309f
C3963 Vop.n211 VSS 0.02243f
C3964 Vop.t147 VSS 0.05571f
C3965 Vop.n212 VSS 0.01854f
C3966 Vop.t134 VSS 0.05571f
C3967 Vop.n213 VSS 0.01908f
C3968 Vop.n214 VSS 0.02243f
C3969 Vop.n215 VSS 0.03309f
C3970 Vop.n216 VSS 0.03309f
C3971 Vop.n217 VSS 0.02243f
C3972 Vop.t136 VSS 0.05571f
C3973 Vop.n218 VSS 0.01852f
C3974 Vop.t85 VSS 0.05571f
C3975 Vop.n219 VSS 0.01908f
C3976 Vop.n220 VSS 0.02243f
C3977 Vop.n221 VSS 0.03309f
C3978 Vop.n222 VSS 0.03309f
C3979 Vop.n223 VSS 0.02243f
C3980 Vop.t67 VSS 0.05571f
C3981 Vop.n224 VSS 0.01854f
C3982 Vop.t55 VSS 0.05571f
C3983 Vop.n225 VSS 0.01908f
C3984 Vop.n226 VSS 0.02243f
C3985 Vop.n227 VSS 0.03309f
C3986 Vop.n228 VSS 0.03309f
C3987 Vop.n229 VSS 0.02243f
C3988 Vop.t59 VSS 0.05571f
C3989 Vop.n230 VSS 0.01852f
C3990 Vop.t62 VSS 0.05571f
C3991 Vop.n231 VSS 0.01908f
C3992 Vop.n232 VSS 0.02243f
C3993 Vop.n233 VSS 0.03309f
C3994 Vop.n234 VSS 0.02727f
C3995 Vop.n235 VSS 0.02243f
C3996 Vop.n236 VSS 0.01908f
C3997 Vop.n237 VSS 0.01854f
C3998 Vop.n238 VSS 0.02243f
C3999 Vop.n239 VSS 0.01908f
C4000 Vop.n240 VSS 0.01854f
C4001 Vop.n241 VSS 0.02243f
C4002 Vop.n242 VSS 0.01908f
C4003 Vop.n243 VSS 0.01854f
C4004 Vop.n244 VSS 0.02243f
C4005 Vop.n245 VSS 0.01908f
C4006 Vop.n246 VSS 0.01852f
C4007 Vop.n247 VSS 0.02243f
C4008 Vop.n248 VSS 0.01908f
C4009 Vop.n249 VSS 0.01852f
C4010 Vop.t52 VSS 0.05751f
C4011 Vop.n250 VSS 0.03792f
C4012 Vop.n251 VSS 0.02727f
C4013 Vop.n252 VSS 0.5989f
C4014 Vop.t21 VSS 0.19518f
C4015 Vop.t10 VSS 0.19518f
C4016 Vop.n253 VSS 0.06146f
C4017 Vop.n254 VSS 1.16723f
C4018 Vop.t24 VSS 0.19518f
C4019 Vop.t2 VSS 0.19518f
C4020 Vop.t4 VSS 0.23082f
C4021 Vop.t5 VSS 0.23082f
C4022 Vop.t3 VSS 0.19518f
C4023 Vop.n255 VSS 0.06155f
C4024 Vop.n256 VSS 0.09392f
C4025 Vop.n257 VSS 1.16723f
C4026 Vop.n258 VSS 2.31072f
C4027 Vop.t26 VSS 0.23082f
C4028 Vop.t25 VSS 0.19579f
C4029 Vop.n259 VSS 0.11161f
C4030 Vop.t6 VSS 0.19579f
C4031 Vop.t17 VSS 0.19518f
C4032 Vop.t0 VSS 0.19518f
C4033 Vop.t12 VSS 0.19518f
C4034 Vop.t15 VSS 0.23082f
C4035 Vop.n260 VSS 0.09392f
C4036 Vop.n261 VSS 0.06155f
C4037 Vop.n262 VSS 0.06146f
C4038 Vop.t16 VSS 0.19518f
C4039 Vop.t23 VSS 0.19518f
C4040 Vop.t14 VSS 0.23082f
C4041 Vop.n263 VSS 0.17865f
C4042 Vop.n264 VSS 0.06155f
C4043 Vop.n265 VSS 0.06146f
C4044 Vop.t19 VSS 0.19518f
C4045 Vop.n266 VSS 0.06045f
C4046 Vop.n267 VSS 0.15458f
C4047 Vop.n268 VSS 2.31072f
C4048 Vop.n269 VSS 0.06984f
C4049 Vop.n270 VSS 0.06045f
C4050 Vop.n271 VSS 0.08052f
C4051 Vop.n272 VSS 1.19722f
C4052 Vop.n273 VSS 0.5989f
C4053 Vop.t7 VSS 0.19579f
C4054 Vop.n274 VSS 0.08052f
C4055 Vop.t18 VSS 0.19518f
C4056 Vop.n275 VSS 0.06045f
C4057 Vop.n276 VSS 0.06984f
C4058 Vop.t1 VSS 0.19518f
C4059 Vop.n277 VSS 0.06146f
C4060 Vop.t13 VSS 0.19518f
C4061 Vop.n278 VSS 0.06155f
C4062 Vop.n279 VSS 0.09392f
C4063 Vop.n280 VSS 1.16723f
C4064 Vop.n281 VSS 1.16723f
C4065 Vop.n282 VSS 0.09392f
C4066 Vop.n283 VSS 0.06155f
C4067 Vop.n284 VSS 0.06146f
C4068 Vop.t8 VSS 0.19579f
C4069 Vop.n285 VSS 0.08052f
C4070 Vop.t20 VSS 0.19518f
C4071 Vop.n286 VSS 0.06045f
C4072 Vop.n287 VSS 0.06984f
C4073 Vop.n288 VSS 1.16723f
C4074 Vop.n289 VSS 1.16723f
C4075 Vop.n290 VSS 0.06984f
C4076 Vop.n291 VSS 0.06048f
C4077 Vop.t9 VSS 0.19579f
C4078 Vop.n292 VSS 0.0805f
C4079 Vop.n293 VSS 0.5989f
C4080 Vop.t27 VSS 0.17463f
C4081 Vop.t22 VSS 0.17463f
C4082 Vop.t29 VSS 0.21025f
C4083 Vop.n294 VSS 0.09395f
C4084 Vop.n295 VSS 0.06152f
C4085 Vop.t11 VSS 0.17463f
C4086 Vop.n296 VSS 0.06149f
C4087 Vop.n297 VSS 0.06984f
C4088 Vop.n298 VSS 0.06045f
C4089 Vop.t28 VSS 0.17525f
C4090 Vop.n299 VSS 0.08052f
C4091 Vop.n300 VSS 2.5047f
C4092 Vop.n301 VSS 2.13738f
C4093 Vop.n302 VSS 0.75558f
C4094 Vop.n303 VSS 1.36318f
C4095 Vop.n304 VSS 1.37174f
C4096 Vop.n305 VSS 0.81959f
C4097 Vop.n306 VSS 0.75558f
C4098 Vop.n307 VSS 0.82708f
C4099 Vop.n308 VSS 0.83329f
C4100 Vop.n309 VSS 3.05878f
C4101 Vop.t157 VSS 9.84155f
C4102 Vop.n310 VSS 2.11077f
C4103 Vop.t158 VSS 3.26226f
C4104 VPin.t0 VSS 2.42795f
C4105 VNin.t0 VSS 2.32294f
C4106 VNin.n0 VSS 0.88126f
C4107 VN.t0 VSS 0.01504f
C4108 VPout.t1 VSS 0.01746f
C4109 VPout.t0 VSS 0.01747f
C4110 VPout.n0 VSS 0.73828f
C4111 CMFBin.t26 VSS 0.34471f
C4112 CMFBin.t25 VSS 0.34323f
C4113 CMFBin.n0 VSS 0.13766f
C4114 CMFBin.t24 VSS 0.34323f
C4115 CMFBin.n1 VSS 0.06786f
C4116 CMFBin.t23 VSS 0.34323f
C4117 CMFBin.n2 VSS 0.06786f
C4118 CMFBin.t22 VSS 0.34323f
C4119 CMFBin.n3 VSS 0.06786f
C4120 CMFBin.t21 VSS 0.34323f
C4121 CMFBin.n4 VSS 0.06786f
C4122 CMFBin.t20 VSS 0.34323f
C4123 CMFBin.n5 VSS 0.06786f
C4124 CMFBin.t19 VSS 0.34323f
C4125 CMFBin.n6 VSS 0.06786f
C4126 CMFBin.t18 VSS 0.34323f
C4127 CMFBin.n7 VSS 0.06786f
C4128 CMFBin.t17 VSS 0.34323f
C4129 CMFBin.n8 VSS 0.06786f
C4130 CMFBin.t16 VSS 0.34323f
C4131 CMFBin.n9 VSS 0.06786f
C4132 CMFBin.t15 VSS 0.34323f
C4133 CMFBin.n10 VSS 0.06786f
C4134 CMFBin.t14 VSS 0.34323f
C4135 CMFBin.n11 VSS 0.05712f
C4136 CMFBin.t0 VSS 0.34471f
C4137 CMFBin.t1 VSS 0.34323f
C4138 CMFBin.n12 VSS 0.13766f
C4139 CMFBin.t2 VSS 0.34323f
C4140 CMFBin.n13 VSS 0.06786f
C4141 CMFBin.t3 VSS 0.34323f
C4142 CMFBin.n14 VSS 0.06786f
C4143 CMFBin.t4 VSS 0.34323f
C4144 CMFBin.n15 VSS 0.06786f
C4145 CMFBin.t5 VSS 0.34323f
C4146 CMFBin.n16 VSS 0.06786f
C4147 CMFBin.t6 VSS 0.34323f
C4148 CMFBin.n17 VSS 0.06786f
C4149 CMFBin.t7 VSS 0.34323f
C4150 CMFBin.n18 VSS 0.06786f
C4151 CMFBin.t8 VSS 0.34323f
C4152 CMFBin.n19 VSS 0.06786f
C4153 CMFBin.t9 VSS 0.34323f
C4154 CMFBin.n20 VSS 0.06786f
C4155 CMFBin.t10 VSS 0.34323f
C4156 CMFBin.n21 VSS 0.06786f
C4157 CMFBin.t11 VSS 0.34323f
C4158 CMFBin.n22 VSS 0.06786f
C4159 CMFBin.t12 VSS 0.34323f
C4160 CMFBin.n23 VSS 0.06605f
C4161 CMFBin.t13 VSS 0.34323f
C4162 CMFBin.n24 VSS 0.09264f
C4163 VP.t0 VSS 0.01506f
C4164 VP.n0 VSS 0.03247f
C4165 VOUTN.n0 VSS 1.00108f
C4166 VOUTN.n1 VSS 0.06878f
C4167 VOUTN.n2 VSS 0.12896f
C4168 VOUTN.n3 VSS 0.09772f
C4169 VOUTN.n4 VSS 0.60732f
C4170 VOUTN.n6 VSS 0.27248f
C4171 VOUTN.t2 VSS 0.31603f
C4172 VOUTN.t8 VSS 0.31562f
C4173 VOUTN.n7 VSS 0.95795f
C4174 VOUTN.n8 VSS 0.39474f
C4175 VOUTN.t14 VSS 0.31603f
C4176 VOUTN.t9 VSS 0.31562f
C4177 VOUTN.n9 VSS 0.95795f
C4178 VOUTN.n10 VSS 0.39474f
C4179 VOUTN.t15 VSS 0.31603f
C4180 VOUTN.t6 VSS 0.31562f
C4181 VOUTN.n11 VSS 0.95795f
C4182 VOUTN.n12 VSS 0.39474f
C4183 VOUTN.t10 VSS 0.31603f
C4184 VOUTN.t7 VSS 0.31562f
C4185 VOUTN.n13 VSS 0.95795f
C4186 VOUTN.t3 VSS 0.21905f
C4187 VOUTN.n14 VSS 0.05193f
C4188 VOUTN.n15 VSS 0.05193f
C4189 VOUTN.n16 VSS 0.05159f
C4190 VOUTN.n17 VSS 0.05193f
C4191 VOUTN.n18 VSS 0.05157f
C4192 VOUTN.n19 VSS 0.05193f
C4193 VOUTN.n20 VSS 0.05159f
C4194 VOUTN.n21 VSS 0.05193f
C4195 VOUTN.n22 VSS 0.05193f
C4196 VOUTN.n23 VSS 0.05159f
C4197 VOUTN.n24 VSS 0.05193f
C4198 VOUTN.n25 VSS 0.05157f
C4199 VOUTN.n26 VSS 0.05193f
C4200 VOUTN.n27 VSS 0.05159f
C4201 VOUTN.n28 VSS 0.05193f
C4202 VOUTN.n29 VSS 0.05193f
C4203 VOUTN.n30 VSS 0.05159f
C4204 VOUTN.n31 VSS 0.05193f
C4205 VOUTN.n32 VSS 0.05157f
C4206 VOUTN.n33 VSS 0.05193f
C4207 VOUTN.n34 VSS 0.05159f
C4208 VOUTN.n35 VSS 0.05193f
C4209 VOUTN.n36 VSS 0.05193f
C4210 VOUTN.n37 VSS 0.05159f
C4211 VOUTN.n38 VSS 0.05193f
C4212 VOUTN.n39 VSS 0.05157f
C4213 VOUTN.n40 VSS 0.02578f
C4214 VOUTN.t24 VSS 0.21959f
C4215 VOUTN.n41 VSS 0.05193f
C4216 VOUTN.n42 VSS 0.05193f
C4217 VOUTN.n43 VSS 0.05159f
C4218 VOUTN.n44 VSS 0.05193f
C4219 VOUTN.n45 VSS 0.05157f
C4220 VOUTN.n46 VSS 0.05193f
C4221 VOUTN.n47 VSS 0.05159f
C4222 VOUTN.n48 VSS 0.05193f
C4223 VOUTN.n49 VSS 0.05193f
C4224 VOUTN.n50 VSS 0.05159f
C4225 VOUTN.n51 VSS 0.05193f
C4226 VOUTN.n52 VSS 0.05157f
C4227 VOUTN.n53 VSS 0.05193f
C4228 VOUTN.n54 VSS 0.05159f
C4229 VOUTN.n55 VSS 0.05193f
C4230 VOUTN.n56 VSS 0.05193f
C4231 VOUTN.n57 VSS 0.05159f
C4232 VOUTN.n58 VSS 0.05193f
C4233 VOUTN.n59 VSS 0.05157f
C4234 VOUTN.n60 VSS 0.05193f
C4235 VOUTN.n61 VSS 0.05159f
C4236 VOUTN.n62 VSS 0.02615f
C4237 VOUTN.n63 VSS 0.03475f
C4238 VOUTN.n64 VSS 0.03475f
C4239 VOUTN.t4 VSS 0.21959f
C4240 VOUTN.n65 VSS 0.02578f
C4241 VOUTN.n66 VSS 0.02579f
C4242 VOUTN.n67 VSS 0.05193f
C4243 VOUTN.n68 VSS 0.05193f
C4244 VOUTN.n69 VSS 0.05193f
C4245 VOUTN.n70 VSS 0.05193f
C4246 VOUTN.n71 VSS 0.05159f
C4247 VOUTN.n72 VSS 0.05157f
C4248 VOUTN.n73 VSS 0.05159f
C4249 VOUTN.n74 VSS 0.05193f
C4250 VOUTN.n75 VSS 0.05193f
C4251 VOUTN.n76 VSS 0.05193f
C4252 VOUTN.n77 VSS 0.05193f
C4253 VOUTN.n78 VSS 0.05159f
C4254 VOUTN.n79 VSS 0.05193f
C4255 VOUTN.n80 VSS 0.05159f
C4256 VOUTN.n81 VSS 0.05157f
C4257 VOUTN.n82 VSS 0.05159f
C4258 VOUTN.n83 VSS 0.05193f
C4259 VOUTN.n84 VSS 0.05193f
C4260 VOUTN.n85 VSS 0.05193f
C4261 VOUTN.n86 VSS 0.05193f
C4262 VOUTN.n87 VSS 0.05159f
C4263 VOUTN.n88 VSS 0.05157f
C4264 VOUTN.n89 VSS 0.05159f
C4265 VOUTN.n90 VSS 0.05193f
C4266 VOUTN.n91 VSS 0.05082f
C4267 VOUTN.t1 VSS 0.21905f
C4268 VOUTN.n92 VSS 0.05193f
C4269 VOUTN.n93 VSS 0.05157f
C4270 VOUTN.t5 VSS 0.21905f
C4271 VOUTN.n94 VSS 0.07511f
C4272 VOUTN.n95 VSS 0.07548f
C4273 VOUTN.n96 VSS 0.02579f
C4274 VOUTN.n97 VSS 0.05193f
C4275 VOUTN.n98 VSS 0.05193f
C4276 VOUTN.n99 VSS 0.05159f
C4277 VOUTN.n100 VSS 0.05193f
C4278 VOUTN.n101 VSS 0.05157f
C4279 VOUTN.n102 VSS 0.05193f
C4280 VOUTN.n103 VSS 0.05159f
C4281 VOUTN.n104 VSS 0.05193f
C4282 VOUTN.n105 VSS 0.05193f
C4283 VOUTN.n106 VSS 0.05159f
C4284 VOUTN.n107 VSS 0.05193f
C4285 VOUTN.n108 VSS 0.05157f
C4286 VOUTN.n109 VSS 0.05193f
C4287 VOUTN.n110 VSS 0.05159f
C4288 VOUTN.n111 VSS 0.05193f
C4289 VOUTN.n112 VSS 0.05193f
C4290 VOUTN.n113 VSS 0.05159f
C4291 VOUTN.n114 VSS 0.05193f
C4292 VOUTN.n115 VSS 0.05157f
C4293 VOUTN.n116 VSS 0.05193f
C4294 VOUTN.n117 VSS 0.05159f
C4295 VOUTN.n118 VSS 0.02615f
C4296 VOUTN.t12 VSS 0.21961f
C4297 VOUTN.n119 VSS 0.19204f
C4298 VOUTN.n120 VSS 0.07889f
C4299 VOUTN.n121 VSS 0.03475f
C4300 VOUTN.t23 VSS 0.21959f
C4301 VOUTN.n122 VSS 0.02578f
C4302 VOUTN.n123 VSS 0.02579f
C4303 VOUTN.n124 VSS 0.05193f
C4304 VOUTN.n125 VSS 0.05193f
C4305 VOUTN.n126 VSS 0.05193f
C4306 VOUTN.n127 VSS 0.05193f
C4307 VOUTN.n128 VSS 0.05159f
C4308 VOUTN.n129 VSS 0.05157f
C4309 VOUTN.n130 VSS 0.05159f
C4310 VOUTN.n131 VSS 0.05193f
C4311 VOUTN.n132 VSS 0.05193f
C4312 VOUTN.n133 VSS 0.05193f
C4313 VOUTN.n134 VSS 0.05193f
C4314 VOUTN.n135 VSS 0.05159f
C4315 VOUTN.n136 VSS 0.05193f
C4316 VOUTN.n137 VSS 0.05159f
C4317 VOUTN.n138 VSS 0.05157f
C4318 VOUTN.n139 VSS 0.05159f
C4319 VOUTN.n140 VSS 0.05193f
C4320 VOUTN.n141 VSS 0.05193f
C4321 VOUTN.n142 VSS 0.05193f
C4322 VOUTN.n143 VSS 0.05193f
C4323 VOUTN.n144 VSS 0.05159f
C4324 VOUTN.n145 VSS 0.05157f
C4325 VOUTN.n146 VSS 0.05159f
C4326 VOUTN.n147 VSS 0.05193f
C4327 VOUTN.n148 VSS 0.05082f
C4328 VOUTN.t18 VSS 0.21905f
C4329 VOUTN.n149 VSS 0.05193f
C4330 VOUTN.n150 VSS 0.05157f
C4331 VOUTN.t16 VSS 0.21905f
C4332 VOUTN.n151 VSS 0.07511f
C4333 VOUTN.n152 VSS 0.07548f
C4334 VOUTN.n153 VSS 0.02579f
C4335 VOUTN.n154 VSS 0.05193f
C4336 VOUTN.n155 VSS 0.05193f
C4337 VOUTN.n156 VSS 0.05159f
C4338 VOUTN.n157 VSS 0.05193f
C4339 VOUTN.n158 VSS 0.05157f
C4340 VOUTN.n159 VSS 0.05193f
C4341 VOUTN.n160 VSS 0.05159f
C4342 VOUTN.n161 VSS 0.05193f
C4343 VOUTN.n162 VSS 0.05193f
C4344 VOUTN.n163 VSS 0.05159f
C4345 VOUTN.n164 VSS 0.05193f
C4346 VOUTN.n165 VSS 0.05157f
C4347 VOUTN.n166 VSS 0.05193f
C4348 VOUTN.n167 VSS 0.05159f
C4349 VOUTN.n168 VSS 0.05193f
C4350 VOUTN.n169 VSS 0.05193f
C4351 VOUTN.n170 VSS 0.05159f
C4352 VOUTN.n171 VSS 0.05193f
C4353 VOUTN.n172 VSS 0.05157f
C4354 VOUTN.n173 VSS 0.05193f
C4355 VOUTN.n174 VSS 0.05159f
C4356 VOUTN.n175 VSS 0.02615f
C4357 VOUTN.t13 VSS 0.21961f
C4358 VOUTN.n176 VSS 0.19204f
C4359 VOUTN.n177 VSS 0.07889f
C4360 VOUTN.n178 VSS 0.03475f
C4361 VOUTN.t0 VSS 0.21959f
C4362 VOUTN.n179 VSS 0.02578f
C4363 VOUTN.n180 VSS 0.02579f
C4364 VOUTN.n181 VSS 0.05193f
C4365 VOUTN.n182 VSS 0.05193f
C4366 VOUTN.n183 VSS 0.05193f
C4367 VOUTN.n184 VSS 0.05193f
C4368 VOUTN.n185 VSS 0.05159f
C4369 VOUTN.n186 VSS 0.05157f
C4370 VOUTN.n187 VSS 0.05159f
C4371 VOUTN.n188 VSS 0.05193f
C4372 VOUTN.n189 VSS 0.05193f
C4373 VOUTN.n190 VSS 0.05193f
C4374 VOUTN.n191 VSS 0.05193f
C4375 VOUTN.n192 VSS 0.05159f
C4376 VOUTN.n193 VSS 0.05193f
C4377 VOUTN.n194 VSS 0.05159f
C4378 VOUTN.n195 VSS 0.05157f
C4379 VOUTN.n196 VSS 0.05159f
C4380 VOUTN.n197 VSS 0.05193f
C4381 VOUTN.n198 VSS 0.05193f
C4382 VOUTN.n199 VSS 0.05193f
C4383 VOUTN.n200 VSS 0.05193f
C4384 VOUTN.n201 VSS 0.05159f
C4385 VOUTN.n202 VSS 0.05157f
C4386 VOUTN.n203 VSS 0.05159f
C4387 VOUTN.n204 VSS 0.05193f
C4388 VOUTN.n205 VSS 0.05082f
C4389 VOUTN.t21 VSS 0.21905f
C4390 VOUTN.n206 VSS 0.05193f
C4391 VOUTN.n207 VSS 0.05157f
C4392 VOUTN.t20 VSS 0.21905f
C4393 VOUTN.n208 VSS 0.07511f
C4394 VOUTN.n209 VSS 0.07548f
C4395 VOUTN.n210 VSS 0.02579f
C4396 VOUTN.n211 VSS 0.05193f
C4397 VOUTN.n212 VSS 0.05193f
C4398 VOUTN.n213 VSS 0.05159f
C4399 VOUTN.n214 VSS 0.05193f
C4400 VOUTN.n215 VSS 0.05157f
C4401 VOUTN.n216 VSS 0.05193f
C4402 VOUTN.n217 VSS 0.05159f
C4403 VOUTN.n218 VSS 0.05193f
C4404 VOUTN.n219 VSS 0.05193f
C4405 VOUTN.n220 VSS 0.05159f
C4406 VOUTN.n221 VSS 0.05193f
C4407 VOUTN.n222 VSS 0.05157f
C4408 VOUTN.n223 VSS 0.05193f
C4409 VOUTN.n224 VSS 0.05159f
C4410 VOUTN.n225 VSS 0.05193f
C4411 VOUTN.n226 VSS 0.05193f
C4412 VOUTN.n227 VSS 0.05159f
C4413 VOUTN.n228 VSS 0.05193f
C4414 VOUTN.n229 VSS 0.05157f
C4415 VOUTN.n230 VSS 0.05193f
C4416 VOUTN.n231 VSS 0.05159f
C4417 VOUTN.n232 VSS 0.02615f
C4418 VOUTN.t17 VSS 0.21961f
C4419 VOUTN.n233 VSS 0.19204f
C4420 VOUTN.n234 VSS 0.07889f
C4421 VOUTN.n235 VSS 1.13932f
C4422 VOUTN.n236 VSS 1.22008f
C4423 VOUTN.n237 VSS 2.20974f
C4424 VOUTN.n238 VSS 0.57237f
C4425 VOUTN.n239 VSS 0.19204f
C4426 VOUTN.t11 VSS 0.21961f
C4427 VOUTN.n240 VSS 0.02579f
C4428 VOUTN.n241 VSS 0.07548f
C4429 VOUTN.n242 VSS 0.07511f
C4430 VOUTN.t19 VSS 0.21905f
C4431 VOUTN.n243 VSS 0.02579f
C4432 VOUTN.n244 VSS 0.05082f
C4433 VOUTN.n245 VSS 1.36849f
C4434 VOUTN.n246 VSS 4.72451f
C4435 VOUTN.n247 VSS 2.57186f
C4436 VOUTN.n248 VSS 2.38736f
C4437 VOUTN.n249 VSS 0.22946f
C4438 VOUTN.n250 VSS 0.18648f
C4439 VOUTN.n251 VSS 0.22946f
C4440 VOUTN.n252 VSS 0.18648f
C4441 VOUTN.n253 VSS 0.13297f
C4442 VOUTN.n254 VSS 0.13584f
C4443 VOUTN.n255 VSS 0.18648f
C4444 VOUTN.n256 VSS 0.18648f
C4445 VOUTN.n257 VSS 0.13584f
C4446 VOUTN.n258 VSS 0.13297f
C4447 VOUTN.n259 VSS 1.29356f
C4448 VOUTN.n260 VSS 2.70023f
C4449 VOUTN.t22 VSS 0.22193f
C4450 VOUTN.n261 VSS 1.20639f
C4451 VOUTN.n262 VSS 0.68217f
C4452 VOUTN.n264 VSS 0.10885f
C4453 VOUTN.n265 VSS 0.10885f
C4454 VOUTN.n266 VSS 0.09772f
C4455 VOUTN.n267 VSS 0.06952f
C4456 VOUTN.n268 VSS 0.00754f
C4457 VOUTN.n270 VSS 0.01134f
C4458 VOUTN.n271 VSS 0.0121f
C4459 VOUTN.n272 VSS 0.01134f
C4460 VOUTN.n273 VSS 0.0121f
C4461 VOUTN.n274 VSS 0.00958f
C4462 VOUTN.n275 VSS 0.0121f
C4463 VOUTN.n276 VSS 0.01134f
C4464 VOUTN.n277 VSS 0.01134f
C4465 VOUTN.n278 VSS 0.0121f
C4466 VOUTN.n279 VSS 0.01768f
C4467 VOUTN.t26 VSS 5.76525f
C4468 VOUTN.n280 VSS 0.02936f
C4469 VOUTN.n281 VSS 0.00777f
C4470 VOUTN.n282 VSS 3.60852f
C4471 VOUTN.t25 VSS 0.1121f
C4472 VOUTN.n283 VSS 7.13476f
C4473 VOUTN.n284 VSS 3.1939f
C4474 VREF.t0 VSS 10.3676f
C4475 CMFBout.t31 VSS 0.21548f
C4476 CMFBout.t14 VSS 0.07365f
C4477 CMFBout.t6 VSS 0.07962f
C4478 CMFBout.n0 VSS 0.05687f
C4479 CMFBout.t32 VSS 0.21548f
C4480 CMFBout.t36 VSS 0.21548f
C4481 CMFBout.t15 VSS 0.0659f
C4482 CMFBout.t7 VSS 0.07186f
C4483 CMFBout.n1 VSS 0.06267f
C4484 CMFBout.n2 VSS 0.24829f
C4485 CMFBout.n3 VSS 0.19561f
C4486 CMFBout.n4 VSS 0.12309f
C4487 CMFBout.n5 VSS 0.12432f
C4488 CMFBout.t13 VSS 0.07365f
C4489 CMFBout.t5 VSS 0.07962f
C4490 CMFBout.n6 VSS 0.05687f
C4491 CMFBout.t33 VSS 0.21548f
C4492 CMFBout.t12 VSS 0.07365f
C4493 CMFBout.t4 VSS 0.07962f
C4494 CMFBout.n7 VSS 0.05687f
C4495 CMFBout.t38 VSS 0.19539f
C4496 CMFBout.t11 VSS 0.07365f
C4497 CMFBout.t3 VSS 0.07962f
C4498 CMFBout.n8 VSS 0.05687f
C4499 CMFBout.t10 VSS 0.07365f
C4500 CMFBout.t2 VSS 0.07962f
C4501 CMFBout.n9 VSS 0.05687f
C4502 CMFBout.t9 VSS 0.07365f
C4503 CMFBout.t1 VSS 0.07962f
C4504 CMFBout.n10 VSS 0.05687f
C4505 CMFBout.t8 VSS 0.07365f
C4506 CMFBout.t0 VSS 0.07962f
C4507 CMFBout.n11 VSS 0.05687f
C4508 CMFBout.t29 VSS 0.07365f
C4509 CMFBout.t22 VSS 0.07962f
C4510 CMFBout.n12 VSS 0.05687f
C4511 CMFBout.t28 VSS 0.07365f
C4512 CMFBout.t21 VSS 0.07962f
C4513 CMFBout.n13 VSS 0.05687f
C4514 CMFBout.t27 VSS 0.07365f
C4515 CMFBout.t20 VSS 0.07962f
C4516 CMFBout.n14 VSS 0.05687f
C4517 CMFBout.t26 VSS 0.07365f
C4518 CMFBout.t19 VSS 0.07962f
C4519 CMFBout.n15 VSS 0.05687f
C4520 CMFBout.t25 VSS 0.07365f
C4521 CMFBout.t18 VSS 0.07962f
C4522 CMFBout.n16 VSS 0.05687f
C4523 CMFBout.t24 VSS 0.07365f
C4524 CMFBout.t17 VSS 0.07962f
C4525 CMFBout.n17 VSS 0.05687f
C4526 CMFBout.t23 VSS 0.0659f
C4527 CMFBout.t16 VSS 0.07186f
C4528 CMFBout.n18 VSS 0.08642f
C4529 CMFBout.n19 VSS 0.30305f
C4530 CMFBout.n20 VSS 0.21042f
C4531 CMFBout.n21 VSS 0.21042f
C4532 CMFBout.n22 VSS 0.21042f
C4533 CMFBout.n23 VSS 0.21042f
C4534 CMFBout.n24 VSS 0.21042f
C4535 CMFBout.n25 VSS 0.21042f
C4536 CMFBout.n26 VSS 0.21042f
C4537 CMFBout.n27 VSS 0.21042f
C4538 CMFBout.n28 VSS 0.17396f
C4539 CMFBout.n29 VSS 0.1906f
C4540 CMFBout.n30 VSS 0.14213f
C4541 CMFBout.n31 VSS 0.22361f
C4542 CMFBout.n32 VSS 0.12309f
C4543 CMFBout.t30 VSS 1.34169f
C4544 CMFBout.n33 VSS 0.0392f
C4545 CMFBout.n34 VSS 1.88967f
C4546 VOUTP.n0 VSS 1.00124f
C4547 VOUTP.n1 VSS 0.06953f
C4548 VOUTP.n2 VSS 0.60742f
C4549 VOUTP.n3 VSS 0.09774f
C4550 VOUTP.n4 VSS 0.10887f
C4551 VOUTP.n5 VSS 0.27102f
C4552 VOUTP.n6 VSS 0.2295f
C4553 VOUTP.t22 VSS 0.31608f
C4554 VOUTP.t23 VSS 0.31567f
C4555 VOUTP.n7 VSS 0.95811f
C4556 VOUTP.n8 VSS 0.3948f
C4557 VOUTP.t8 VSS 0.31608f
C4558 VOUTP.t24 VSS 0.31567f
C4559 VOUTP.n9 VSS 0.95811f
C4560 VOUTP.n10 VSS 0.3948f
C4561 VOUTP.t2 VSS 0.31608f
C4562 VOUTP.t3 VSS 0.31567f
C4563 VOUTP.n11 VSS 0.95811f
C4564 VOUTP.n12 VSS 0.3948f
C4565 VOUTP.t1 VSS 0.31608f
C4566 VOUTP.t20 VSS 0.31567f
C4567 VOUTP.n13 VSS 0.95811f
C4568 VOUTP.t14 VSS 0.21908f
C4569 VOUTP.n14 VSS 0.05194f
C4570 VOUTP.n15 VSS 0.05194f
C4571 VOUTP.n16 VSS 0.0516f
C4572 VOUTP.n17 VSS 0.05194f
C4573 VOUTP.n18 VSS 0.05157f
C4574 VOUTP.n19 VSS 0.05194f
C4575 VOUTP.n20 VSS 0.0516f
C4576 VOUTP.n21 VSS 0.05194f
C4577 VOUTP.n22 VSS 0.05194f
C4578 VOUTP.n23 VSS 0.0516f
C4579 VOUTP.n24 VSS 0.05194f
C4580 VOUTP.n25 VSS 0.05157f
C4581 VOUTP.n26 VSS 0.05194f
C4582 VOUTP.n27 VSS 0.0516f
C4583 VOUTP.n28 VSS 0.05194f
C4584 VOUTP.n29 VSS 0.05194f
C4585 VOUTP.n30 VSS 0.0516f
C4586 VOUTP.n31 VSS 0.05194f
C4587 VOUTP.n32 VSS 0.05157f
C4588 VOUTP.n33 VSS 0.05194f
C4589 VOUTP.n34 VSS 0.0516f
C4590 VOUTP.n35 VSS 0.05194f
C4591 VOUTP.n36 VSS 0.05194f
C4592 VOUTP.n37 VSS 0.0516f
C4593 VOUTP.n38 VSS 0.05194f
C4594 VOUTP.n39 VSS 0.05157f
C4595 VOUTP.n40 VSS 0.02579f
C4596 VOUTP.t19 VSS 0.21962f
C4597 VOUTP.n41 VSS 0.05194f
C4598 VOUTP.n42 VSS 0.05194f
C4599 VOUTP.n43 VSS 0.0516f
C4600 VOUTP.n44 VSS 0.05194f
C4601 VOUTP.n45 VSS 0.05157f
C4602 VOUTP.n46 VSS 0.05194f
C4603 VOUTP.n47 VSS 0.0516f
C4604 VOUTP.n48 VSS 0.05194f
C4605 VOUTP.n49 VSS 0.05194f
C4606 VOUTP.n50 VSS 0.0516f
C4607 VOUTP.n51 VSS 0.05194f
C4608 VOUTP.n52 VSS 0.05157f
C4609 VOUTP.n53 VSS 0.05194f
C4610 VOUTP.n54 VSS 0.0516f
C4611 VOUTP.n55 VSS 0.05194f
C4612 VOUTP.n56 VSS 0.05194f
C4613 VOUTP.n57 VSS 0.0516f
C4614 VOUTP.n58 VSS 0.05194f
C4615 VOUTP.n59 VSS 0.05157f
C4616 VOUTP.n60 VSS 0.05194f
C4617 VOUTP.n61 VSS 0.0516f
C4618 VOUTP.n62 VSS 0.02615f
C4619 VOUTP.n63 VSS 0.03476f
C4620 VOUTP.n64 VSS 0.03476f
C4621 VOUTP.t7 VSS 0.21962f
C4622 VOUTP.n65 VSS 0.02579f
C4623 VOUTP.n66 VSS 0.0258f
C4624 VOUTP.n67 VSS 0.05194f
C4625 VOUTP.n68 VSS 0.05194f
C4626 VOUTP.n69 VSS 0.05194f
C4627 VOUTP.n70 VSS 0.05194f
C4628 VOUTP.n71 VSS 0.0516f
C4629 VOUTP.n72 VSS 0.05157f
C4630 VOUTP.n73 VSS 0.0516f
C4631 VOUTP.n74 VSS 0.05194f
C4632 VOUTP.n75 VSS 0.05194f
C4633 VOUTP.n76 VSS 0.05194f
C4634 VOUTP.n77 VSS 0.05194f
C4635 VOUTP.n78 VSS 0.0516f
C4636 VOUTP.n79 VSS 0.05194f
C4637 VOUTP.n80 VSS 0.0516f
C4638 VOUTP.n81 VSS 0.05157f
C4639 VOUTP.n82 VSS 0.0516f
C4640 VOUTP.n83 VSS 0.05194f
C4641 VOUTP.n84 VSS 0.05194f
C4642 VOUTP.n85 VSS 0.05194f
C4643 VOUTP.n86 VSS 0.05194f
C4644 VOUTP.n87 VSS 0.0516f
C4645 VOUTP.n88 VSS 0.05157f
C4646 VOUTP.n89 VSS 0.0516f
C4647 VOUTP.n90 VSS 0.05194f
C4648 VOUTP.n91 VSS 0.05083f
C4649 VOUTP.t5 VSS 0.21908f
C4650 VOUTP.n92 VSS 0.05194f
C4651 VOUTP.n93 VSS 0.05157f
C4652 VOUTP.t16 VSS 0.21908f
C4653 VOUTP.n94 VSS 0.07512f
C4654 VOUTP.n95 VSS 0.07549f
C4655 VOUTP.n96 VSS 0.0258f
C4656 VOUTP.n97 VSS 0.05194f
C4657 VOUTP.n98 VSS 0.05194f
C4658 VOUTP.n99 VSS 0.0516f
C4659 VOUTP.n100 VSS 0.05194f
C4660 VOUTP.n101 VSS 0.05157f
C4661 VOUTP.n102 VSS 0.05194f
C4662 VOUTP.n103 VSS 0.0516f
C4663 VOUTP.n104 VSS 0.05194f
C4664 VOUTP.n105 VSS 0.05194f
C4665 VOUTP.n106 VSS 0.0516f
C4666 VOUTP.n107 VSS 0.05194f
C4667 VOUTP.n108 VSS 0.05157f
C4668 VOUTP.n109 VSS 0.05194f
C4669 VOUTP.n110 VSS 0.0516f
C4670 VOUTP.n111 VSS 0.05194f
C4671 VOUTP.n112 VSS 0.05194f
C4672 VOUTP.n113 VSS 0.0516f
C4673 VOUTP.n114 VSS 0.05194f
C4674 VOUTP.n115 VSS 0.05157f
C4675 VOUTP.n116 VSS 0.05194f
C4676 VOUTP.n117 VSS 0.0516f
C4677 VOUTP.n118 VSS 0.02615f
C4678 VOUTP.t4 VSS 0.21964f
C4679 VOUTP.n119 VSS 0.19207f
C4680 VOUTP.n120 VSS 0.07891f
C4681 VOUTP.n121 VSS 1.1395f
C4682 VOUTP.n122 VSS 0.03476f
C4683 VOUTP.t11 VSS 0.21962f
C4684 VOUTP.n123 VSS 0.02579f
C4685 VOUTP.n124 VSS 0.0258f
C4686 VOUTP.n125 VSS 0.05194f
C4687 VOUTP.n126 VSS 0.05194f
C4688 VOUTP.n127 VSS 0.05194f
C4689 VOUTP.n128 VSS 0.05194f
C4690 VOUTP.n129 VSS 0.0516f
C4691 VOUTP.n130 VSS 0.05157f
C4692 VOUTP.n131 VSS 0.0516f
C4693 VOUTP.n132 VSS 0.05194f
C4694 VOUTP.n133 VSS 0.05194f
C4695 VOUTP.n134 VSS 0.05194f
C4696 VOUTP.n135 VSS 0.05194f
C4697 VOUTP.n136 VSS 0.0516f
C4698 VOUTP.n137 VSS 0.05194f
C4699 VOUTP.n138 VSS 0.0516f
C4700 VOUTP.n139 VSS 0.05157f
C4701 VOUTP.n140 VSS 0.0516f
C4702 VOUTP.n141 VSS 0.05194f
C4703 VOUTP.n142 VSS 0.05194f
C4704 VOUTP.n143 VSS 0.05194f
C4705 VOUTP.n144 VSS 0.05194f
C4706 VOUTP.n145 VSS 0.0516f
C4707 VOUTP.n146 VSS 0.05157f
C4708 VOUTP.n147 VSS 0.0516f
C4709 VOUTP.n148 VSS 0.05194f
C4710 VOUTP.n149 VSS 0.05083f
C4711 VOUTP.t21 VSS 0.21908f
C4712 VOUTP.n150 VSS 0.05194f
C4713 VOUTP.n151 VSS 0.05157f
C4714 VOUTP.t0 VSS 0.21908f
C4715 VOUTP.n152 VSS 0.07512f
C4716 VOUTP.n153 VSS 0.07549f
C4717 VOUTP.n154 VSS 0.0258f
C4718 VOUTP.n155 VSS 0.05194f
C4719 VOUTP.n156 VSS 0.05194f
C4720 VOUTP.n157 VSS 0.0516f
C4721 VOUTP.n158 VSS 0.05194f
C4722 VOUTP.n159 VSS 0.05157f
C4723 VOUTP.n160 VSS 0.05194f
C4724 VOUTP.n161 VSS 0.0516f
C4725 VOUTP.n162 VSS 0.05194f
C4726 VOUTP.n163 VSS 0.05194f
C4727 VOUTP.n164 VSS 0.0516f
C4728 VOUTP.n165 VSS 0.05194f
C4729 VOUTP.n166 VSS 0.05157f
C4730 VOUTP.n167 VSS 0.05194f
C4731 VOUTP.n168 VSS 0.0516f
C4732 VOUTP.n169 VSS 0.05194f
C4733 VOUTP.n170 VSS 0.05194f
C4734 VOUTP.n171 VSS 0.0516f
C4735 VOUTP.n172 VSS 0.05194f
C4736 VOUTP.n173 VSS 0.05157f
C4737 VOUTP.n174 VSS 0.05194f
C4738 VOUTP.n175 VSS 0.0516f
C4739 VOUTP.n176 VSS 0.02615f
C4740 VOUTP.t9 VSS 0.21964f
C4741 VOUTP.n177 VSS 0.19207f
C4742 VOUTP.n178 VSS 0.07891f
C4743 VOUTP.n179 VSS 1.22027f
C4744 VOUTP.n180 VSS 0.03476f
C4745 VOUTP.t18 VSS 0.21962f
C4746 VOUTP.n181 VSS 0.02579f
C4747 VOUTP.n182 VSS 0.0258f
C4748 VOUTP.n183 VSS 0.05194f
C4749 VOUTP.n184 VSS 0.05194f
C4750 VOUTP.n185 VSS 0.05194f
C4751 VOUTP.n186 VSS 0.05194f
C4752 VOUTP.n187 VSS 0.0516f
C4753 VOUTP.n188 VSS 0.05157f
C4754 VOUTP.n189 VSS 0.0516f
C4755 VOUTP.n190 VSS 0.05194f
C4756 VOUTP.n191 VSS 0.05194f
C4757 VOUTP.n192 VSS 0.05194f
C4758 VOUTP.n193 VSS 0.05194f
C4759 VOUTP.n194 VSS 0.0516f
C4760 VOUTP.n195 VSS 0.05194f
C4761 VOUTP.n196 VSS 0.0516f
C4762 VOUTP.n197 VSS 0.05157f
C4763 VOUTP.n198 VSS 0.0516f
C4764 VOUTP.n199 VSS 0.05194f
C4765 VOUTP.n200 VSS 0.05194f
C4766 VOUTP.n201 VSS 0.05194f
C4767 VOUTP.n202 VSS 0.05194f
C4768 VOUTP.n203 VSS 0.0516f
C4769 VOUTP.n204 VSS 0.05157f
C4770 VOUTP.n205 VSS 0.0516f
C4771 VOUTP.n206 VSS 0.05194f
C4772 VOUTP.n207 VSS 0.05083f
C4773 VOUTP.t10 VSS 0.21908f
C4774 VOUTP.n208 VSS 0.05194f
C4775 VOUTP.n209 VSS 0.05157f
C4776 VOUTP.t13 VSS 0.21908f
C4777 VOUTP.n210 VSS 0.07512f
C4778 VOUTP.n211 VSS 0.07549f
C4779 VOUTP.n212 VSS 0.0258f
C4780 VOUTP.n213 VSS 0.05194f
C4781 VOUTP.n214 VSS 0.05194f
C4782 VOUTP.n215 VSS 0.0516f
C4783 VOUTP.n216 VSS 0.05194f
C4784 VOUTP.n217 VSS 0.05157f
C4785 VOUTP.n218 VSS 0.05194f
C4786 VOUTP.n219 VSS 0.0516f
C4787 VOUTP.n220 VSS 0.05194f
C4788 VOUTP.n221 VSS 0.05194f
C4789 VOUTP.n222 VSS 0.0516f
C4790 VOUTP.n223 VSS 0.05194f
C4791 VOUTP.n224 VSS 0.05157f
C4792 VOUTP.n225 VSS 0.05194f
C4793 VOUTP.n226 VSS 0.0516f
C4794 VOUTP.n227 VSS 0.05194f
C4795 VOUTP.n228 VSS 0.05194f
C4796 VOUTP.n229 VSS 0.0516f
C4797 VOUTP.n230 VSS 0.05194f
C4798 VOUTP.n231 VSS 0.05157f
C4799 VOUTP.n232 VSS 0.05194f
C4800 VOUTP.n233 VSS 0.0516f
C4801 VOUTP.n234 VSS 0.02615f
C4802 VOUTP.t17 VSS 0.21964f
C4803 VOUTP.n235 VSS 0.19207f
C4804 VOUTP.n236 VSS 0.07891f
C4805 VOUTP.n237 VSS 2.2101f
C4806 VOUTP.n238 VSS 0.57246f
C4807 VOUTP.n239 VSS 0.19207f
C4808 VOUTP.t6 VSS 0.21964f
C4809 VOUTP.n240 VSS 0.0258f
C4810 VOUTP.n241 VSS 0.07549f
C4811 VOUTP.n242 VSS 0.07512f
C4812 VOUTP.t12 VSS 0.21908f
C4813 VOUTP.n243 VSS 0.0258f
C4814 VOUTP.n244 VSS 0.05083f
C4815 VOUTP.n245 VSS 1.36444f
C4816 VOUTP.n246 VSS 4.72953f
C4817 VOUTP.n247 VSS 2.57227f
C4818 VOUTP.n248 VSS 2.38774f
C4819 VOUTP.n249 VSS 0.18651f
C4820 VOUTP.n250 VSS 0.2295f
C4821 VOUTP.n251 VSS 0.18651f
C4822 VOUTP.n252 VSS 0.1345f
C4823 VOUTP.n253 VSS 0.13586f
C4824 VOUTP.n254 VSS 0.18651f
C4825 VOUTP.n255 VSS 0.18651f
C4826 VOUTP.n256 VSS 0.13586f
C4827 VOUTP.n257 VSS 0.13299f
C4828 VOUTP.n258 VSS 1.29377f
C4829 VOUTP.n260 VSS 2.70066f
C4830 VOUTP.t15 VSS 0.22197f
C4831 VOUTP.n261 VSS 1.20658f
C4832 VOUTP.n262 VSS 0.12899f
C4833 VOUTP.n263 VSS 0.68228f
C4834 VOUTP.n265 VSS 0.10887f
C4835 VOUTP.n266 VSS 0.09774f
C4836 VOUTP.n267 VSS 0.06879f
C4837 VOUTP.n268 VSS 0.00777f
C4838 VOUTP.n270 VSS 0.01134f
C4839 VOUTP.n271 VSS 0.0121f
C4840 VOUTP.n272 VSS 0.01134f
C4841 VOUTP.n273 VSS 0.0121f
C4842 VOUTP.n274 VSS 0.00958f
C4843 VOUTP.n275 VSS 0.0121f
C4844 VOUTP.n276 VSS 0.01134f
C4845 VOUTP.n277 VSS 0.01134f
C4846 VOUTP.n278 VSS 0.0121f
C4847 VOUTP.n279 VSS 0.02936f
C4848 VOUTP.t26 VSS 5.76618f
C4849 VOUTP.n280 VSS 0.01768f
C4850 VOUTP.n281 VSS 0.00754f
C4851 VOUTP.n282 VSS 3.6091f
C4852 VOUTP.t25 VSS 0.11212f
C4853 VOUTP.n283 VSS 7.1359f
C4854 VOUTP.n284 VSS 3.19441f
C4855 IB.t2 VSS 0.09702f
C4856 IB.t1 VSS 1.38335f
C4857 IB.t0 VSS 0.69155f
C4858 IB.n0 VSS 0.72956f
.ends
